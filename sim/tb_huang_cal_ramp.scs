// Testbench for Huang Recursive V6 calibration + post-cal ramp (Binary CDAC)
//
// Phase 1 (0-75us): Full 7-target recursive calibration
// Phase 2 (82-492us): Ramp input, normal SAR conversion
//
// Includes SAR_LOGIC_0716 for normal SAR conversion mode.
// DEC handles both calibration (CAL_RST=0) and decoding (CAL_RST=1, cal_done=1).
//
// CDAC TOPOLOGY: Low {1,2,4,8,16,32}=63C, Bridge 2C, High {1A,1R,2,4,8,16,32}=64C
// H=65, total weight 4287 > 4095, 14 decision bits

simulator lang=spectre
global 0

ahdl_include "DEC_CAL_PHY_HUANG_V6.va"
ahdl_include "SWITCH_CAL.va"
ahdl_include "CAL_CMP_TB.va"
ahdl_include "SAR_LOGIC_0716.va"

// Parameters loaded from external file for campaign sweep
include "./params.scs"

// ==========================================================================
// Power and references
// ==========================================================================
// Dummy vsource forces calbp to be recognized as top-level parameter
VCALBP_DUMMY (DUMMY_CALBP 0) vsource dc=calbp

VAGND (AGND 0) vsource dc=0
VDGND (DGND 0) vsource dc=0
VAVDD (AVDD AGND) vsource dc=vdd
VDVDD (DVDD DGND) vsource dc=vdd
VVCM  (VCM AGND) vsource dc=vdd/2
VREFP (VREFP AGND) vsource dc=vdd
VREFN (VREFN AGND) vsource dc=0

// Input: DC at VCM during calibration, ramp during normal conversion
// Ramp: 0 to VDD over 410us, starting at 82us (7us after cal ends at 75us)
VVIP  (VIP AGND) vsource type=pwl \
    wave=[0.0 0.9  75u 0.9  82u 0.0  492u 1.8]
VVIN  (VIN AGND) vsource dc=vdd/2

// ==========================================================================
// Clock and control signals
// ==========================================================================
// RST: sampling reset (100ns period, 14.05ns active)
VRST  (RST AGND) vsource type=pulse val0=0 val1=vdd period=100n \
    delay=100p rise=10p fall=10p width=14.05n

// RST1: top-plate reset / frame control (150ns period, 14n active)
VRST1 (RST1 AGND) vsource type=pulse val0=0 val1=vdd period=150n \
    delay=100p rise=10p fall=10p width=14n

// SOUT: conversion complete strobe (coincident with RST rising edge)
VSOUT (SOUT DGND) vsource type=pulse val0=0 val1=vdd period=100n \
    delay=98n rise=10p fall=10p width=2n

// CLK00: master clock window
VCLK00 (CLK00 DGND) vsource type=pulse val0=0 val1=vdd period=100n \
    delay=20n rise=10p fall=10p width=79n

// CLK_SAR: normal SAR comparison clock (5ns period, 2ns active)
VCLKSAR (CLK_SAR DGND) vsource type=pulse val0=0 val1=vdd period=5n \
    delay=20n rise=10p fall=10p width=2n

// CAL_CLK: calibration SAR clock (10ns period)
VCALCLK (CAL_CLK DGND) vsource type=pulse val0=0 val1=vdd period=10n \
    delay=20n rise=10p fall=10p width=5n

// CAL_RST: calibration reset (active low, 75us pulse)
VCALRST (CAL_RST DGND) vsource type=pulse val0=vdd val1=0 period=10m \
    delay=50n rise=10p fall=10p width=75u

// ==========================================================================
// DEC_CAL_PHY -> SAR_LOGIC BITN bridge (0V DC source = ideal wire)
//
// DEC reads BP[0:13] at SOUT to get raw SAR decisions.
// SAR_LOGIC BITN=1 means positive step (include weight).
// So we bridge: BP[i] = BN[i] (SAR_LOGIC BITN output)
// ==========================================================================
VBP0  (BN0  BP0)  vsource dc=0
VBP1  (BN1  BP1)  vsource dc=0
VBP2  (BN2  BP2)  vsource dc=0
VBP3  (BN3  BP3)  vsource dc=0
VBP4  (BN4  BP4)  vsource dc=0
VBP5  (BN5  BP5)  vsource dc=0
VBP6  (BN6  BP6)  vsource dc=0
VBP7  (BN7  BP7)  vsource dc=0
VBP8  (BN8  BP8)  vsource dc=0
VBP9  (BN9  BP9)  vsource dc=0
VBP10 (BN10 BP10) vsource dc=0
VBP11 (BN11 BP11) vsource dc=0
VBP12 (BN12 BP12) vsource dc=0
VBP13 (BN13 BP13) vsource dc=0
// BPX nets from SAR_LOGIC BITP are unused by DEC

// ==========================================================================
// SAR_LOGIC_0716
// ==========================================================================
XSAR (BN13 BN12 BN11 BN10 BN9 BN8 BN7 BN6 BN5 BN4 BN3 BN2 BN1 BN0 \
    BPX13 BPX12 BPX11 BPX10 BPX9 BPX8 BPX7 BPX6 BPX5 BPX4 BPX3 BPX2 BPX1 BPX0 \
    CCLK COMN DGND DVDD RST \
    SET13 SET12 SET11 SET10 SET9 SET8 SET7 SET6 SET5 SET4 SET3 SET2 SET1 SET0 \
    ) SAR_LOGIC_0716

// ==========================================================================
// DEC_CAL_PHY (Huang V6)
// CCLK = DEC CLK output drives both comparator and SAR_LOGIC
// ==========================================================================
XDEC (B11 B10 B9 B8 B7 B6 B5 B4 B3 B2 B1 B0 \
    BP0 BP1 BP2 BP3 BP4 BP5 BP6 BP7 BP8 BP9 BP10 BP11 BP12 BP13 \
    DGND DVDD SOUT COMP COMN RST1 CAL_RST CLK_SAR CLK00 CCLK \
    DC0 DC1 DC2 DC3 DC4 DC5 DC6 DC7 DC8 DC9 DC10 DC11 DC12 \
    UC0 UC1 UC2 UC3 UC4 UC5 UC6 UC7 UC8 UC9 UC10 UC11 UC12 \
    CAL DONE ERR CAL_CLK) DEC_CAL_PHY \
    DEBUG=2 CMP_SWAP=0 NOM_H1_WEIGHT=65 \
    FRAC_BITS=6 AVG_PAIRS_LOG2=5 \
    WEIGHT_TOL=0.20 MIN_CAL_HEADROOM_LSB=2.0 \
    FAIL_ON_ENDPOINT=0 CAL_BYPASS=calbp APPLY_CAL_WEIGHT=1 \
    REVERT_ON_ERROR=1 REMOVE_REDUNDANCY_OFFSET=1

// ==========================================================================
// SWITCH_CAL (SET[0:12] only - terminal stage 13 has no physical cap)
// ==========================================================================
XSW (AGND AVDD \
    D1 D2 D3 D4 D5 D6 D7 D8 D9 D10 D11 D12 D13 \
    BN0 BN1 BN2 BN3 BN4 BN5 BN6 BN7 BN8 BN9 BN10 BN11 BN12 BN13 \
    BPX0 BPX1 BPX2 BPX3 BPX4 BPX5 BPX6 BPX7 BPX8 BPX9 BPX10 BPX11 BPX12 BPX13 \
    U1 U2 U3 U4 U5 U6 U7 U8 U9 U10 U11 U12 U13 \
    N P RST RST1 \
    SET0 SET1 SET2 SET3 SET4 SET5 SET6 SET7 SET8 SET9 SET10 SET11 SET12 \
    VCM VIN VIP VREFN VREFP \
    DC0 DC1 DC2 DC3 DC4 DC5 DC6 DC7 DC8 DC9 DC10 DC11 DC12 \
    UC0 UC1 UC2 UC3 UC4 UC5 UC6 UC7 UC8 UC9 UC10 UC11 UC12 \
    CAL CAL_CLK) SWITCH_CAL

// ==========================================================================
// Comparator model
// ==========================================================================
XCMP (P N CCLK RST COMP COMN DGND DVDD) CAL_CMP_TB

// ==========================================================================
// Physical CDAC with H=65 (C_B = 2C integer bridge)
// ==========================================================================
// P-side low segment
CD1  (D1  PD) capacitor c=1*cunit
CD2  (D2  PD) capacitor c=2*cunit
CD3  (D3  PD) capacitor c=4*cunit
CD4  (D4  PD) capacitor c=8*cunit
CD5  (D5  PD) capacitor c=16*cunit
CD6  (D6  PD) capacitor c=32*cunit

// P-side bridge
CDBR (PD  P)  capacitor c=2*cunit

// P-side high segment
CD7  (D7  P)  capacitor c=md8*1*cunit
CD8  (D8  P)  capacitor c=md9*1*cunit
CD9  (D9  P)  capacitor c=md10*2*cunit
CD10 (D10 P)  capacitor c=md11*4*cunit
CD11 (D11 P)  capacitor c=md12*8*cunit
CD12 (D12 P)  capacitor c=md13*16*cunit
CD13 (D13 P)  capacitor c=md14*32*cunit

// N-side low segment
CU1  (U1  PU) capacitor c=1*cunit
CU2  (U2  PU) capacitor c=2*cunit
CU3  (U3  PU) capacitor c=4*cunit
CU4  (U4  PU) capacitor c=8*cunit
CU5  (U5  PU) capacitor c=16*cunit
CU6  (U6  PU) capacitor c=32*cunit

// N-side bridge
CUBR (PU  N)  capacitor c=2*cunit

// N-side high segment
CU7  (U7  N)  capacitor c=mu8*1*cunit
CU8  (U8  N)  capacitor c=mu9*1*cunit
CU9  (U9  N)  capacitor c=mu10*2*cunit
CU10 (U10 N)  capacitor c=mu11*4*cunit
CU11 (U11 N)  capacitor c=mu12*8*cunit
CU12 (U12 N)  capacitor c=mu13*16*cunit
CU13 (U13 N)  capacitor c=mu14*32*cunit

// Top-plate parasitics (removed: affected bridge ratio and nominal weights)
// CPP (P AGND) capacitor c=5f
// CPN (N AGND) capacitor c=5f

// ==========================================================================
// Simulation
// ==========================================================================
tran tran stop=80u maxstep=500p method=gear2only \
    reltol=1e-5 vabstol=1e-8 iabstol=1e-12

save CAL DONE ERR CCLK CAL_CLK COMP COMN P N PD PU \
    B0 B1 B2 B3 B4 B5 B6 B7 B8 B9 B10 B11 \
    VIP VIN \
    BN0 BN1 BN2 BN3 BN4 BN5 BN6 BN7 BN8 BN9 BN10 BN11 BN12 BN13 \
    BPX0 BPX1 BPX2 BPX3 BPX4 BPX5 BPX6 BPX7 BPX8 BPX9 BPX10 BPX11 BPX12 BPX13 \
    DC0 DC1 DC2 DC3 DC4 DC5 DC6 DC7 DC8 DC9 DC10 DC11 DC12 \
    UC0 UC1 UC2 UC3 UC4 UC5 UC6 UC7 UC8 UC9 UC10 UC11 UC12
saveOptions options save=selected
