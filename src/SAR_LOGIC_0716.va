// Ideal 14-decision non-binary SAR logic replacement.
// Clean V6: compare-then-commit sequencing for the signed differential CDAC.
//
// Exact positional interface of the existing SAR_LOGIC_0716 cell:
//   BITN<13:0>, BITP<13:0>, CCLK, COMN, DGND, DVDD, PRST, SET<0:13>
//
// Physical/SAR numbering:
//   stage 0  -> BITP/N<13>, SET<0>   (MSB, binary CDAC High 32C)
//   ...
//   stage 12 -> BITP/N<1>,  SET<12>  (last physical capacitor)
//   stage 13 -> BITP/N<0>,  SET<13>  (terminal comparator-only decision)
//
// IMPORTANT SEQUENCING
// --------------------
// This CDAC is not operated as "apply a trial, compare, then undo/keep".
// Each physical branch is initially held at VCM.  The comparator first observes
// the current residue; only after that comparison is the current branch committed
// to one of the two differential reference states.
//
// With SWITCH_CAL NORMAL_REF_SWAP=1:
//   BITP=1, BITN=0 -> negative differential step
//   BITP=0, BITN=1 -> positive differential step
//
// Therefore:
//   P > N -> COMP=1, COMN=0 -> commit BITP=1 (negative correction)
//   P < N -> COMP=0, COMN=1 -> commit BITN=1 (positive correction)
//
// The terminal stage stores the final comparator sign in BITP/N<0> but does not
// switch a physical capacitor.
//
// PRST behavior:
//   Falling edge arms a fresh conversion with every physical branch still at VCM.
//   Rising edge stops an unfinished sequence but does not erase the completed RAW
//   code, because SOUT is coincident with PRST in the existing testbench.

`include "constants.vams"
`include "disciplines.vams"

module SAR_LOGIC_0716 (
    BITN, BITP, CCLK, COMN, DGND, DVDD, PRST, SET
);
    output [13:0] BITN;
    output [13:0] BITP;
    input CCLK, COMN;
    inout DGND, DVDD;
    input PRST;
    output [0:13] SET;

    electrical [13:0] BITN, BITP;
    electrical CCLK, COMN, DGND, DVDD, PRST;
    electrical [0:13] SET;

    parameter real VTH_FRACTION = 0.5 from (0.0:1.0);
    parameter real TD = 20p from [0.0:inf);
    parameter real TR = 10p from (0.0:inf);
    parameter real TF = 10p from (0.0:inf);
    parameter real RDRV = 1.0 from (0.0:inf);

    integer bitp_mask_i;
    integer bitn_mask_i;
    integer set_mask_i;
    integer stage_i;
    integer active_i;
    integer decision_i;
    integer bit_index_i;

    real vlogic;
    real vth;
    genvar g;

    analog begin
        vlogic = V(DVDD, DGND);
        vth = VTH_FRACTION * vlogic;

        @(initial_step) begin
            bitp_mask_i = 0;
            bitn_mask_i = 0;
            set_mask_i = 0;
            stage_i = 0;
            active_i = 0;
            decision_i = 0;
            bit_index_i = 13;
        end

        // Sampling/precharge has ended.  Arm stage 0, but do not apply an MSB
        // trial.  The first comparator cycle must observe the sampled residue.
        @(cross(V(PRST, DGND) - vth, -1)) begin
            bitp_mask_i = 0;
            bitn_mask_i = 0;
            set_mask_i = 0;
            stage_i = 0;
            active_i = 1;
        end

        // Preserve completed RAW code for the coincident SOUT latch.
        @(cross(V(PRST, DGND) - vth, +1)) begin
            active_i = 0;
        end

        // CCLK occurs after the comparator CLK pulse.  Store the already-latched
        // comparator sign, then commit the corresponding physical branch.
        @(cross(V(CCLK, DGND) - vth, +1)) begin
            if (active_i != 0) begin
                decision_i = (V(COMN, DGND) < vth) ? 1 : 0;
                bit_index_i = 13 - stage_i;

                if (decision_i != 0) begin
                    // P>N: apply the negative correction.
                    bitp_mask_i = bitp_mask_i | (1 << bit_index_i);
                    bitn_mask_i = bitn_mask_i & ~(1 << bit_index_i);
                end else begin
                    // P<N: apply the positive correction.
                    bitp_mask_i = bitp_mask_i & ~(1 << bit_index_i);
                    bitn_mask_i = bitn_mask_i | (1 << bit_index_i);
                end

                if (stage_i <= 12) begin
                    // SET is asserted only after the decision, so the selected
                    // physical capacitor moves from VCM to its committed state.
                    set_mask_i = set_mask_i | (1 << stage_i);
                    stage_i = stage_i + 1;
                end else begin
                    // stage 13 is terminal and has no physical capacitor.
                    set_mask_i = set_mask_i | (1 << 13);
                    active_i = 0;
                end
            end
        end

        // Finite-R drivers avoid rigid-branch loops.
        for (g = 0; g <= 13; g = g + 1) begin
            I(BITP[g], DGND) <+ (V(BITP[g], DGND) -
                vlogic * transition((bitp_mask_i >> g) & 1,
                    TD, TR, TF)) / RDRV;
            I(BITN[g], DGND) <+ (V(BITN[g], DGND) -
                vlogic * transition((bitn_mask_i >> g) & 1,
                    TD, TR, TF)) / RDRV;
            I(SET[g], DGND) <+ (V(SET[g], DGND) -
                vlogic * transition((set_mask_i >> g) & 1,
                    TD, TR, TF)) / RDRV;
        end
    end
endmodule
