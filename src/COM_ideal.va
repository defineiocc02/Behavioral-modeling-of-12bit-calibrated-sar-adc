// Clean V6 ideal latched differential comparator with calibration-only
// deterministic sub-LSB threshold dither.
//
// REQUIRED positional interface:
//   COM_ideal CLK COMN COMP N P CAL
//
// Polarity:
//   P > N -> COMP=1, COMN=0
//   P < N -> COMP=0, COMN=1
//
// During CAL=1, a sub-LSB threshold dither is applied every comparator decision
// using CAL_LSB_V and the dither index driven externally via DITHER_IDX[4:0].
// DITHER_IDX is set by DEC per pair, same for D+ and D-.
// During CAL=0 the threshold dither is exactly zero, so bypass and
// calibrated A/B tests are valid.

`include "constants.vams"
`include "disciplines.vams"

module COM_ideal (CLK, COMN, COMP, N, P, CAL, DITHER_IDX);
    input  CLK, N, P, CAL;
    input [4:0] DITHER_IDX;
    output COMN, COMP;

    electrical CLK, COMN, COMP, N, P, CAL;
    electrical [4:0] DITHER_IDX;

    parameter real VHIGH = 1.8 from (0.0:inf);
    parameter real VTH_CLK = 0.9 from (0.0:inf);
    parameter real VTH_CAL = 0.9 from (0.0:inf);
    parameter real VOS = 0.0;

    parameter real TD = 20p from [0.0:inf);
    parameter real TR = 10p from (0.0:inf);
    parameter real TF = 10p from (0.0:inf);
    parameter real RDRV = 1.0 from (0.0:inf);
    parameter integer TIE_P_GT_N = 0 from [0:1];

    // Sub-LSB foreground-calibration settings.
    parameter integer CAL_DITHER_ENABLE = 1 from [0:1];
    // Differential top-plate voltage corresponding to one calibration code LSB.
    // Default: 2*(VREFP-VREFN)/4287 = 3.6/4287 = 0.839748 mV.
    parameter real CAL_LSB_V = 0.839748m from (0.0:inf);
    parameter integer DITHER_LEVELS = 32 from [2:256];
    integer comp_state_i;
    integer dither_index_i;
    integer cal_i;

    real vdiff_i;
    real dither_v_i;

    analog begin
        cal_i = (V(CAL) > VTH_CAL) ? 1 : 0;

        @(initial_step) begin
            comp_state_i = 0;
            dither_index_i = 0;
            dither_v_i = 0.0;
        end

        // Every new calibration run restarts the deterministic threshold sweep.
        @(cross(V(CAL) - VTH_CAL, +1)) begin
            dither_index_i = 0;
        end

        @(cross(V(CAL) - VTH_CAL, -1)) begin
            dither_index_i = 0;
            dither_v_i = 0.0;
        end

        @(cross(V(CLK) - VTH_CLK, +1)) begin
            if ((cal_i != 0) && (CAL_DITHER_ENABLE != 0)) begin
                // Dither index driven externally by DEC via DITHER_IDX bus.
                dither_index_i = 0;
                if (V(DITHER_IDX[4]) > VTH_CAL) dither_index_i = dither_index_i + 16;
                if (V(DITHER_IDX[3]) > VTH_CAL) dither_index_i = dither_index_i + 8;
                if (V(DITHER_IDX[2]) > VTH_CAL) dither_index_i = dither_index_i + 4;
                if (V(DITHER_IDX[1]) > VTH_CAL) dither_index_i = dither_index_i + 2;
                if (V(DITHER_IDX[0]) > VTH_CAL) dither_index_i = dither_index_i + 1;
                if (dither_index_i >= DITHER_LEVELS)
                    dither_index_i = 0;

                // Midpoint-uniform sequence over [-0.5,+0.5) calibration LSB.
                dither_v_i = CAL_LSB_V *
                    (((1.0*dither_index_i + 0.5) /
                      (1.0*DITHER_LEVELS)) - 0.5);
            end else begin
                dither_v_i = 0.0;
            end

            vdiff_i = V(P, N) - VOS - dither_v_i;

            if (vdiff_i > 0.0)
                comp_state_i = 1;
            else if (vdiff_i < 0.0)
                comp_state_i = 0;
            else
                comp_state_i = TIE_P_GT_N;
        end

        // Finite-R drivers avoid rigid-branch loops.
        I(COMP) <+ (V(COMP) -
            VHIGH * transition(comp_state_i, TD, TR, TF)) / RDRV;
        I(COMN) <+ (V(COMN) -
            VHIGH * transition(1-comp_state_i, TD, TR, TF)) / RDRV;
    end
endmodule
