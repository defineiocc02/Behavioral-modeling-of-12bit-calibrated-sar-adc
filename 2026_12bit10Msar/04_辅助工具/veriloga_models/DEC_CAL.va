`include "constants.vams"
`include "disciplines.vams"

// VCM CDAC foreground weight-calibration and calibrated-decoding model.
//
// This model is aligned with the existing project signal chain:
//   SAR_LOGIC BITP<12:0> -> PN_BUF BP<12:0> -> DEC
//
// The core interface keeps the same top-level net names as the existing DEC:
//   BP<12:0>, Bit<11:0>, SOUT, DVDD and DGND.
//
// Nominal decision weights are not the physical capacitor labels.  The first
// comparison precedes the first capacitor switch, so the correct BP decision
// weights are:
//   {raw11..raw0} = {1024,512,256,128,48,32,20,12,8,4,2,1}
//
// ACT_W* are known plant weights used by this golden behavioral model.  They
// must be replaced with weights extracted from MC/PEX or a closed-loop
// measurement engine.  This module does not directly drive the physical CDAC.
module DEC_CAL (
    Bit, BP, DGND, DVDD, SOUT,
    CAL_CLK, CAL_RST, CAL_START,
    CAL_DONE, CAL_BUSY, CAL_ERR, CODE_VALID,
    W_CAL
);

    output [11:0] Bit;
    input [12:0] BP;
    inout DGND, DVDD;
    input SOUT;
    input CAL_CLK, CAL_RST, CAL_START;

    output CAL_DONE, CAL_BUSY, CAL_ERR, CODE_VALID;
    output [11:0] W_CAL;

    electrical [11:0] Bit;
    electrical [12:0] BP;
    electrical DGND, DVDD;
    electrical SOUT;
    electrical CAL_CLK, CAL_RST, CAL_START;

    electrical CAL_DONE, CAL_BUSY, CAL_ERR, CODE_VALID;
    electrical [11:0] W_CAL;

    parameter real VTH_FRACTION = 0.5 from (0.0:1.0);
    parameter real TD = 0.0 from [0.0:inf);
    parameter real TR = 20p from (0.0:inf);
    parameter real TF = 20p from (0.0:inf);

    // BP signals are used directly by the existing DEC, so both defaults are 0.
    // Set both to 1 only when connecting the complementary BN bus instead.
    parameter integer FIRST_INVERT = 0;
    parameter integer RAW_INVERT = 0;

    // Normalize the calibrated raw-bit weights to a 2047-LSB total span.
    parameter integer APPLY_GAIN_NORMALIZATION = 1;
    parameter real TARGET_RAW_SUM = 2047.0 from (0.0:inf);

    // Golden plant decision weights.  ACT_W0 is the 1-LSB anchor.
    parameter real ACT_W0  = 1.0;
    parameter real ACT_W1  = 2.0;
    parameter real ACT_W2  = 4.0;
    parameter real ACT_W3  = 8.0;
    parameter real ACT_W4  = 12.0;
    parameter real ACT_W5  = 20.0;
    parameter real ACT_W6  = 32.0;
    parameter real ACT_W7  = 48.0;
    parameter real ACT_W8  = 128.0;
    parameter real ACT_W9  = 256.0;
    parameter real ACT_W10 = 512.0;
    parameter real ACT_W11 = 1024.0;

    // Differential two-phase measurement model, in raw-code LSB units.
    parameter real CMP_OFFSET_LSB = 0.0;
    parameter real POS_ERR_LSB = 0.0;
    parameter real NEG_ERR_LSB = 0.0;
    parameter real MEAS_NOISE_LSB = 0.0 from [0.0:inf);
    parameter integer NOISE_SEED_POS = 13579;
    parameter integer NOISE_SEED_NEG = 24680;

    parameter real WEIGHT_TOL = 0.05 from (0.0:1.0);
    parameter integer MAX_CAL_CYCLES = 32 from [11:inf);
    parameter real WMON_SCALE = 1m from (0.0:inf);
    parameter integer DEBUG = 0;

    // cal_state: 0=IDLE, 1=CALIBRATING, 2=DONE, 3=ERROR.
    integer cal_state;
    integer start_pending;
    integer cal_idx;
    integer cal_cycles;

    integer cal_done_i;
    integer cal_busy_i;
    integer cal_error_i;
    integer code_valid_i;

    integer adc_code;
    integer first_bit;
    integer r0, r1, r2, r3, r4, r5;
    integer r6, r7, r8, r9, r10, r11;
    integer b0, b1, b2, b3, b4, b5;
    integer b6, b7, b8, b9, b10, b11;

    integer seed_pos;
    integer seed_neg;

    real cw0, cw1, cw2, cw3, cw4, cw5;
    real cw6, cw7, cw8, cw9, cw10, cw11;

    real vlogic;
    real vth;
    real actual_target;
    real actual_wall;
    real calibrated_wall;
    real nominal_target;
    real true_residual;
    real noise_pos;
    real noise_neg;
    real meas_pos;
    real meas_neg;
    real residual_est;
    real candidate;
    real lower_limit;
    real upper_limit;
    real weight_sum;
    real gain_scale;
    real magnitude;

    analog begin
        vlogic = V(DVDD, DGND);
        vth = VTH_FRACTION * vlogic;

        @(initial_step) begin
            cal_state = 0;
            start_pending = 0;
            cal_idx = 1;
            cal_cycles = 0;
            cal_done_i = 0;
            cal_busy_i = 0;
            cal_error_i = 0;
            code_valid_i = 0;
            adc_code = 0;
            seed_pos = NOISE_SEED_POS;
            seed_neg = NOISE_SEED_NEG;

            cw0  = 1.0;
            cw1  = 2.0;
            cw2  = 4.0;
            cw3  = 8.0;
            cw4  = 12.0;
            cw5  = 20.0;
            cw6  = 32.0;
            cw7  = 48.0;
            cw8  = 128.0;
            cw9  = 256.0;
            cw10 = 512.0;
            cw11 = 1024.0;
        end

        @(cross(V(CAL_RST, DGND) - vth, +1)) begin
            cal_state = 0;
            start_pending = 0;
            cal_idx = 1;
            cal_cycles = 0;
            cal_done_i = 0;
            cal_busy_i = 0;
            cal_error_i = 0;
            code_valid_i = 0;
            adc_code = 0;
            seed_pos = NOISE_SEED_POS;
            seed_neg = NOISE_SEED_NEG;

            cw0  = 1.0;
            cw1  = 2.0;
            cw2  = 4.0;
            cw3  = 8.0;
            cw4  = 12.0;
            cw5  = 20.0;
            cw6  = 32.0;
            cw7  = 48.0;
            cw8  = 128.0;
            cw9  = 256.0;
            cw10 = 512.0;
            cw11 = 1024.0;
        end

        // CAL_START only arms the operation.  The next CAL_CLK edge enters CAL.
        @(cross(V(CAL_START, DGND) - vth, +1)) begin
            if ((V(CAL_RST, DGND) < vth) && (cal_state != 1)) begin
                start_pending = 1;
                cal_done_i = 0;
                cal_error_i = 0;
            end
        end

        @(cross(V(CAL_CLK, DGND) - vth, +1)) begin
            if (V(CAL_RST, DGND) < vth) begin
                if (start_pending == 1) begin
                    start_pending = 0;
                    cal_state = 1;
                    cal_idx = 1;
                    cal_cycles = 0;
                    cal_done_i = 0;
                    cal_busy_i = 1;
                    cal_error_i = 0;
                    seed_pos = NOISE_SEED_POS;
                    seed_neg = NOISE_SEED_NEG;

                    cw0  = 1.0;
                    cw1  = 2.0;
                    cw2  = 4.0;
                    cw3  = 8.0;
                    cw4  = 12.0;
                    cw5  = 20.0;
                    cw6  = 32.0;
                    cw7  = 48.0;
                    cw8  = 128.0;
                    cw9  = 256.0;
                    cw10 = 512.0;
                    cw11 = 1024.0;

                    if (DEBUG != 0)
                        $strobe("DEC_CAL start t=%g", $abstime);

                end else if (cal_state == 1) begin
                    cal_cycles = cal_cycles + 1;

                    if (cal_cycles > MAX_CAL_CYCLES) begin
                        cal_state = 3;
                        cal_busy_i = 0;
                        cal_done_i = 0;
                        cal_error_i = 1;
                    end else begin
                        actual_target = 0.0;
                        actual_wall = 0.0;
                        calibrated_wall = 0.0;
                        nominal_target = 0.0;

                        case (cal_idx)
                            1: begin
                                nominal_target = 2.0;
                                actual_target = ACT_W1;
                                actual_wall = ACT_W0;
                                calibrated_wall = cw0;
                            end
                            2: begin
                                nominal_target = 4.0;
                                actual_target = ACT_W2;
                                actual_wall = ACT_W1 + ACT_W0;
                                calibrated_wall = cw1 + cw0;
                            end
                            3: begin
                                nominal_target = 8.0;
                                actual_target = ACT_W3;
                                actual_wall = ACT_W2 + ACT_W1 + ACT_W0;
                                calibrated_wall = cw2 + cw1 + cw0;
                            end
                            4: begin
                                nominal_target = 12.0;
                                actual_target = ACT_W4;
                                actual_wall = ACT_W3 + ACT_W2;
                                calibrated_wall = cw3 + cw2;
                            end
                            5: begin
                                nominal_target = 20.0;
                                actual_target = ACT_W5;
                                actual_wall = ACT_W4 + ACT_W3;
                                calibrated_wall = cw4 + cw3;
                            end
                            6: begin
                                nominal_target = 32.0;
                                actual_target = ACT_W6;
                                actual_wall = ACT_W5 + ACT_W4;
                                calibrated_wall = cw5 + cw4;
                            end
                            7: begin
                                nominal_target = 48.0;
                                actual_target = ACT_W7;
                                actual_wall = ACT_W6 + ACT_W4 + ACT_W2;
                                calibrated_wall = cw6 + cw4 + cw2;
                            end
                            8: begin
                                nominal_target = 128.0;
                                actual_target = ACT_W8;
                                actual_wall = ACT_W0 + ACT_W1 + ACT_W2 + ACT_W3 +
                                    ACT_W4 + ACT_W5 + ACT_W6 + ACT_W7;
                                calibrated_wall = cw0 + cw1 + cw2 + cw3 +
                                    cw4 + cw5 + cw6 + cw7;
                            end
                            9: begin
                                nominal_target = 256.0;
                                actual_target = ACT_W9;
                                actual_wall = ACT_W0 + ACT_W1 + ACT_W2 + ACT_W3 +
                                    ACT_W4 + ACT_W5 + ACT_W6 + ACT_W7 + ACT_W8;
                                calibrated_wall = cw0 + cw1 + cw2 + cw3 + cw4 +
                                    cw5 + cw6 + cw7 + cw8;
                            end
                            10: begin
                                nominal_target = 512.0;
                                actual_target = ACT_W10;
                                actual_wall = ACT_W0 + ACT_W1 + ACT_W2 + ACT_W3 +
                                    ACT_W4 + ACT_W5 + ACT_W6 + ACT_W7 + ACT_W8 + ACT_W9;
                                calibrated_wall = cw0 + cw1 + cw2 + cw3 + cw4 +
                                    cw5 + cw6 + cw7 + cw8 + cw9;
                            end
                            11: begin
                                nominal_target = 1024.0;
                                actual_target = ACT_W11;
                                actual_wall = ACT_W0 + ACT_W1 + ACT_W2 + ACT_W3 +
                                    ACT_W4 + ACT_W5 + ACT_W6 + ACT_W7 + ACT_W8 +
                                    ACT_W9 + ACT_W10;
                                calibrated_wall = cw0 + cw1 + cw2 + cw3 + cw4 +
                                    cw5 + cw6 + cw7 + cw8 + cw9 + cw10;
                            end
                        endcase

                        true_residual = actual_target - actual_wall;
                        noise_pos = MEAS_NOISE_LSB *
                            $rdist_normal(seed_pos, 0, 1000000) / 1000000.0;
                        noise_neg = MEAS_NOISE_LSB *
                            $rdist_normal(seed_neg, 0, 1000000) / 1000000.0;

                        meas_pos = true_residual + CMP_OFFSET_LSB +
                            POS_ERR_LSB + noise_pos;
                        meas_neg = -true_residual + CMP_OFFSET_LSB +
                            NEG_ERR_LSB + noise_neg;
                        residual_est = 0.5 * (meas_pos - meas_neg);
                        candidate = calibrated_wall + residual_est;

                        lower_limit = nominal_target * (1.0 - WEIGHT_TOL);
                        upper_limit = nominal_target * (1.0 + WEIGHT_TOL);

                        if ((candidate <= 0.0) ||
                            (candidate < lower_limit) ||
                            (candidate > upper_limit)) begin
                            cal_state = 3;
                            cal_busy_i = 0;
                            cal_done_i = 0;
                            cal_error_i = 1;

                            if (DEBUG != 0)
                                $strobe("DEC_CAL error idx=%0d candidate=%g", cal_idx, candidate);
                        end else begin
                            case (cal_idx)
                                1:  cw1  = candidate;
                                2:  cw2  = candidate;
                                3:  cw3  = candidate;
                                4:  cw4  = candidate;
                                5:  cw5  = candidate;
                                6:  cw6  = candidate;
                                7:  cw7  = candidate;
                                8:  cw8  = candidate;
                                9:  cw9  = candidate;
                                10: cw10 = candidate;
                                11: cw11 = candidate;
                            endcase

                            if (DEBUG != 0)
                                $strobe("DEC_CAL weight idx=%0d value=%g", cal_idx, candidate);

                            if (cal_idx == 11) begin
                                cal_state = 2;
                                cal_busy_i = 0;
                                cal_done_i = 1;
                            end else begin
                                cal_idx = cal_idx + 1;
                            end
                        end
                    end
                end
            end
        end

        // Decode one complete SAR result on the existing SOUT rising edge.
        @(cross(V(SOUT, DGND) - vth, +1)) begin
            if ((V(CAL_RST, DGND) < vth) &&
                (cal_done_i == 1) &&
                (cal_error_i == 0)) begin

                first_bit = (V(BP[12], DGND) > vth);
                r0  = (V(BP[0], DGND)  > vth);
                r1  = (V(BP[1], DGND)  > vth);
                r2  = (V(BP[2], DGND)  > vth);
                r3  = (V(BP[3], DGND)  > vth);
                r4  = (V(BP[4], DGND)  > vth);
                r5  = (V(BP[5], DGND)  > vth);
                r6  = (V(BP[6], DGND)  > vth);
                r7  = (V(BP[7], DGND)  > vth);
                r8  = (V(BP[8], DGND)  > vth);
                r9  = (V(BP[9], DGND)  > vth);
                r10 = (V(BP[10], DGND) > vth);
                r11 = (V(BP[11], DGND) > vth);

                if (FIRST_INVERT != 0)
                    first_bit = 1 - first_bit;

                if (RAW_INVERT != 0) begin
                    r0  = 1 - r0;
                    r1  = 1 - r1;
                    r2  = 1 - r2;
                    r3  = 1 - r3;
                    r4  = 1 - r4;
                    r5  = 1 - r5;
                    r6  = 1 - r6;
                    r7  = 1 - r7;
                    r8  = 1 - r8;
                    r9  = 1 - r9;
                    r10 = 1 - r10;
                    r11 = 1 - r11;
                end

                weight_sum = cw0 + cw1 + cw2 + cw3 + cw4 + cw5 +
                    cw6 + cw7 + cw8 + cw9 + cw10 + cw11;

                if ((APPLY_GAIN_NORMALIZATION != 0) && (weight_sum > 0.0))
                    gain_scale = TARGET_RAW_SUM / weight_sum;
                else
                    gain_scale = 1.0;

                magnitude = gain_scale * (
                      r0  * cw0
                    + r1  * cw1
                    + r2  * cw2
                    + r3  * cw3
                    + r4  * cw4
                    + r5  * cw5
                    + r6  * cw6
                    + r7  * cw7
                    + r8  * cw8
                    + r9  * cw9
                    + r10 * cw10
                    + r11 * cw11
                );

                adc_code = first_bit * 2048 + $rtoi(magnitude + 0.5);

                if (adc_code < 0)
                    adc_code = 0;
                else if (adc_code > 4095)
                    adc_code = 4095;

                code_valid_i = 1;

                if (DEBUG != 0)
                    $strobe("DEC_CAL decode t=%g code=%0d", $abstime, adc_code);
            end
        end

        @(cross(V(SOUT, DGND) - vth, -1)) begin
            code_valid_i = 0;
        end

        @(final_step) begin
            if (DEBUG != 0) begin
                $strobe("DEC_CAL final done=%0d error=%0d code=%0d", cal_done_i, cal_error_i, adc_code);
                $strobe("DEC_CAL weights={%g,%g,%g,%g,%g,%g,%g,%g,%g,%g,%g,%g}",
                    cw0, cw1, cw2, cw3, cw4, cw5,
                    cw6, cw7, cw8, cw9, cw10, cw11);
            end
        end

        b0  = (adc_code      ) & 1;
        b1  = (adc_code >>  1) & 1;
        b2  = (adc_code >>  2) & 1;
        b3  = (adc_code >>  3) & 1;
        b4  = (adc_code >>  4) & 1;
        b5  = (adc_code >>  5) & 1;
        b6  = (adc_code >>  6) & 1;
        b7  = (adc_code >>  7) & 1;
        b8  = (adc_code >>  8) & 1;
        b9  = (adc_code >>  9) & 1;
        b10 = (adc_code >> 10) & 1;
        b11 = (adc_code >> 11) & 1;

        // Keep the transition() input discrete and apply live supply tracking
        // outside it.  This avoids VACOMP-1116 continuous-input warnings.
        V(CAL_DONE, DGND) <+ vlogic * transition(cal_done_i ? 1.0 : 0.0, TD, TR, TF);
        V(CAL_BUSY, DGND) <+ vlogic * transition(cal_busy_i ? 1.0 : 0.0, TD, TR, TF);
        V(CAL_ERR, DGND) <+ vlogic * transition(cal_error_i ? 1.0 : 0.0, TD, TR, TF);
        V(CODE_VALID, DGND) <+ vlogic * transition(code_valid_i ? 1.0 : 0.0, TD, TR, TF);

        V(Bit[0], DGND)  <+ vlogic * transition(b0  ? 1.0 : 0.0, TD, TR, TF);
        V(Bit[1], DGND)  <+ vlogic * transition(b1  ? 1.0 : 0.0, TD, TR, TF);
        V(Bit[2], DGND)  <+ vlogic * transition(b2  ? 1.0 : 0.0, TD, TR, TF);
        V(Bit[3], DGND)  <+ vlogic * transition(b3  ? 1.0 : 0.0, TD, TR, TF);
        V(Bit[4], DGND)  <+ vlogic * transition(b4  ? 1.0 : 0.0, TD, TR, TF);
        V(Bit[5], DGND)  <+ vlogic * transition(b5  ? 1.0 : 0.0, TD, TR, TF);
        V(Bit[6], DGND)  <+ vlogic * transition(b6  ? 1.0 : 0.0, TD, TR, TF);
        V(Bit[7], DGND)  <+ vlogic * transition(b7  ? 1.0 : 0.0, TD, TR, TF);
        V(Bit[8], DGND)  <+ vlogic * transition(b8  ? 1.0 : 0.0, TD, TR, TF);
        V(Bit[9], DGND)  <+ vlogic * transition(b9  ? 1.0 : 0.0, TD, TR, TF);
        V(Bit[10], DGND) <+ vlogic * transition(b10 ? 1.0 : 0.0, TD, TR, TF);
        V(Bit[11], DGND) <+ vlogic * transition(b11 ? 1.0 : 0.0, TD, TR, TF);

        V(W_CAL[0], DGND)  <+ transition(cw0  * WMON_SCALE, TD, TR, TF);
        V(W_CAL[1], DGND)  <+ transition(cw1  * WMON_SCALE, TD, TR, TF);
        V(W_CAL[2], DGND)  <+ transition(cw2  * WMON_SCALE, TD, TR, TF);
        V(W_CAL[3], DGND)  <+ transition(cw3  * WMON_SCALE, TD, TR, TF);
        V(W_CAL[4], DGND)  <+ transition(cw4  * WMON_SCALE, TD, TR, TF);
        V(W_CAL[5], DGND)  <+ transition(cw5  * WMON_SCALE, TD, TR, TF);
        V(W_CAL[6], DGND)  <+ transition(cw6  * WMON_SCALE, TD, TR, TF);
        V(W_CAL[7], DGND)  <+ transition(cw7  * WMON_SCALE, TD, TR, TF);
        V(W_CAL[8], DGND)  <+ transition(cw8  * WMON_SCALE, TD, TR, TF);
        V(W_CAL[9], DGND)  <+ transition(cw9  * WMON_SCALE, TD, TR, TF);
        V(W_CAL[10], DGND) <+ transition(cw10 * WMON_SCALE, TD, TR, TF);
        V(W_CAL[11], DGND) <+ transition(cw11 * WMON_SCALE, TD, TR, TF);
    end
endmodule
