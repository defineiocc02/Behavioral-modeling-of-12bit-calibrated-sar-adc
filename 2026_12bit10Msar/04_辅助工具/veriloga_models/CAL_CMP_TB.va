// Testbench-only StrongArm polarity model for the DEC_CAL_PHY closed-loop
// regression.  It is not one of the two modules inserted into the ADC.

`include "constants.vams"
`include "disciplines.vams"

module CAL_CMP_TB (P, N, CLK, RST, COMP, COMN, DGND, DVDD);
    input P, N, CLK, RST;
    output COMP, COMN;
    inout DGND, DVDD;

    electrical P, N, CLK, RST, COMP, COMN, DGND, DVDD;

    parameter real VOFF = 0.0;
    parameter real TD = 200p from [0.0:inf);
    parameter real TR = 20p from (0.0:inf);
    parameter real TF = 20p from (0.0:inf);

    integer comp_i;
    integer comn_i;
    real vlogic;
    real vth;

    analog begin
        vlogic = V(DVDD, DGND);
        vth = 0.5 * vlogic;

        @(initial_step) begin
            comp_i = 1;
            comn_i = 1;
        end

        // This matches DEC_CAL_PHY CMP_SWAP=0:
        // P>N makes COMP fall and COMN remain high.
        @(cross(V(CLK, DGND) - vth, +1)) begin
            if (V(P, N) > VOFF) begin
                comp_i = 0;
                comn_i = 1;
            end else begin
                comp_i = 1;
                comn_i = 0;
            end
        end

        @(cross(V(CLK, DGND) - vth, -1)) begin
            comp_i = 1;
            comn_i = 1;
        end

        @(cross(V(RST, DGND) - vth, +1)) begin
            comp_i = 1;
            comn_i = 1;
        end

        V(COMP, DGND) <+ vlogic * transition(comp_i, TD, TR, TF);
        V(COMN, DGND) <+ vlogic * transition(comn_i, TD, TR, TF);
    end
endmodule
