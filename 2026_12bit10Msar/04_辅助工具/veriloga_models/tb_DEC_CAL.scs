simulator lang=spectre
global 0

parameters vdd=1.8

ahdl_include "DEC_CAL.va"

VSSSRC (VSS 0) vsource dc=0 type=dc
VDDSRC (VDD VSS) vsource dc=vdd type=dc

// One-shot foreground-calibration controls for a 330 ns smoke test.
VCALRST (CAL_RST VSS) vsource type=pulse val0=0 val1=vdd delay=1n \
    rise=10p fall=10p width=2n period=1u
VCALSTART (CAL_START VSS) vsource type=pulse val0=0 val1=vdd delay=5n \
    rise=10p fall=10p width=2n period=1u
VCALCLK (CAL_CLK VSS) vsource type=pulse val0=0 val1=vdd delay=10n \
    rise=10p fall=10p width=5n period=10n

// Four decode vectors sampled at RAW_VALID = 160, 210, 260, 310 ns:
//   1) first=0, raw=0                         -> code 0
//   2) first=0, raw7=1, raw4=1                -> code 60
//   3) first=1, raw=0                         -> code 2048
//   4) first=1, raw=all ones                  -> code 4095
VRAWVALID (RAW_VALID VSS) vsource type=pulse val0=0 val1=vdd delay=160n \
    rise=10p fall=10p width=5n period=50n

VFIRST (FIRST VSS) vsource type=pwl wave=[0 0 239n 0 240n vdd 330n vdd]

VRAW0  (RAW0  VSS) vsource type=pwl wave=[0 0 289n 0 290n vdd 330n vdd]
VRAW1  (RAW1  VSS) vsource type=pwl wave=[0 0 289n 0 290n vdd 330n vdd]
VRAW2  (RAW2  VSS) vsource type=pwl wave=[0 0 289n 0 290n vdd 330n vdd]
VRAW3  (RAW3  VSS) vsource type=pwl wave=[0 0 289n 0 290n vdd 330n vdd]
VRAW4  (RAW4  VSS) vsource type=pwl wave=[0 0 189n 0 190n vdd 239n vdd \
    240n 0 289n 0 290n vdd 330n vdd]
VRAW5  (RAW5  VSS) vsource type=pwl wave=[0 0 289n 0 290n vdd 330n vdd]
VRAW6  (RAW6  VSS) vsource type=pwl wave=[0 0 289n 0 290n vdd 330n vdd]
VRAW7  (RAW7  VSS) vsource type=pwl wave=[0 0 189n 0 190n vdd 239n vdd \
    240n 0 289n 0 290n vdd 330n vdd]
VRAW8  (RAW8  VSS) vsource type=pwl wave=[0 0 289n 0 290n vdd 330n vdd]
VRAW9  (RAW9  VSS) vsource type=pwl wave=[0 0 289n 0 290n vdd 330n vdd]
VRAW10 (RAW10 VSS) vsource type=pwl wave=[0 0 289n 0 290n vdd 330n vdd]
VRAW11 (RAW11 VSS) vsource type=pwl wave=[0 0 289n 0 290n vdd 330n vdd]

XDUT (D11 D10 D9 D8 D7 D6 \
    D5 D4 D3 D2 D1 D0 \
    FIRST RAW11 RAW10 RAW9 RAW8 RAW7 \
    RAW6 RAW5 RAW4 RAW3 RAW2 RAW1 RAW0 \
    VSS VDD RAW_VALID \
    CAL_CLK CAL_RST CAL_START \
    CAL_DONE CAL_BUSY CAL_ERR CODE_VALID \
    W11_MON W10_MON W9_MON W8_MON W7_MON W6_MON \
    W5_MON W4_MON W3_MON W2_MON W1_MON W0_MON \
) DEC_CAL DEBUG=1

simulatorOptions options temp=27 tnom=27 reltol=1e-4 vabstol=1u \
    iabstol=1p gmin=1e-12 maxnotes=20 maxwarns=20
tran tran stop=330n maxstep=100p errpreset=conservative
saveOptions options save=allpub
