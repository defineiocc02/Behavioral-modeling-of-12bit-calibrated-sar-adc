// CODEX_SANDBOX_VARIANT cal_bypass=1 stop=14.1u save_raw=0 minimal_save=0 fft_save=1 va=800m normalize_range=0 avg_pairs_log2=0 tran_noise=off noisefmin=disabled
// FROZEN_SOURCE=D:\ReedZhao\Document\Obsidian\日常\10_项目区\2026_12bit10Msar\04_辅助工具\veriloga_models\codex_calibration_20260717\variants\mismatch_campaign_high3_paper_vertical\sample01_paper_vertical_high3_source.scs
// Design: 12bit_50M_SAR/test_12bit50MSAR_AMS_final_0716
simulator lang=spectre
global 0
parameters temperature=27.0 td=18n IB=300n C=4f N=59 M=128 W1=500n W2=1u WK=2u W3=2u W4=3u W5=4u W6=5u W7=8u W8=12u va=800m Vref=1 vdd=1.8 tdac=2n tdel=5n cbin=1p vcmpre=0.9 F1=8 F4=2 WK1=500n FSR=2 FM7=8 csup=2 tlatch=1.5n FFB=1 VBIASN=800m VBIASP=900m WS=4u L=1 F2=4 WCM=4u F3=F4
include "/home/meow/Desktop/TSMC18RF/tsmc18rf/../models/spectre/rf018.scs" section=tt
include "/home/meow/Desktop/TSMC18RF/tsmc18rf/../models/spectre/rf018.scs" section=tt_3v
include "/home/meow/Desktop/TSMC18RF/tsmc18rf/../models/spectre/rf018.scs" section=tt_na
include "/home/meow/Desktop/TSMC18RF/tsmc18rf/../models/spectre/rf018.scs" section=tt_3vna
include "/home/meow/Desktop/TSMC18RF/tsmc18rf/../models/spectre/rf018.scs" section=tt_m
include "/home/meow/Desktop/TSMC18RF/tsmc18rf/../models/spectre/rf018.scs" section=tt_3m
include "/home/meow/Desktop/TSMC18RF/tsmc18rf/../models/spectre/rf018.scs" section=tt_bip
include "/home/meow/Desktop/TSMC18RF/tsmc18rf/../models/spectre/rf018.scs" section=tt_bip3
include "/home/meow/Desktop/TSMC18RF/tsmc18rf/../models/spectre/rf018.scs" section=dio
include "/home/meow/Desktop/TSMC18RF/tsmc18rf/../models/spectre/rf018.scs" section=dio3
include "/home/meow/Desktop/TSMC18RF/tsmc18rf/../models/spectre/rf018.scs" section=dio_dnw
include "/home/meow/Desktop/TSMC18RF/tsmc18rf/../models/spectre/rf018.scs" section=tt_res
include "/home/meow/Desktop/TSMC18RF/tsmc18rf/../models/spectre/rf018.scs" section=tt_mim
include "/home/meow/Desktop/TSMC18RF/tsmc18rf/../models/spectre/rf018.scs" section=tt_rfmos
include "/home/meow/Desktop/TSMC18RF/tsmc18rf/../models/spectre/rf018.scs" section=tt_rfmos33
include "/home/meow/Desktop/TSMC18RF/tsmc18rf/../models/spectre/rf018.scs" section=tt_rfmim
include "/home/meow/Desktop/TSMC18RF/tsmc18rf/../models/spectre/rf018.scs" section=tt_rfind
include "/home/meow/Desktop/TSMC18RF/tsmc18rf/../models/spectre/rf018.scs" section=tt_rfmvar
include "/home/meow/Desktop/TSMC18RF/tsmc18rf/../models/spectre/rf018.scs" section=tt_rfjvar
include "/home/meow/Desktop/TSMC18RF/tsmc18rf/../models/spectre/rf018.scs" section=tt_rfres_sa
include "/home/meow/Desktop/TSMC18RF/tsmc18rf/../models/spectre/rf018.scs" section=tt_rfres_rpo
include "/home/meow/Desktop/TSMC18RF/tsmc18rf/../models/spectre/rf018.scs" section=tt_rfres_hri
include "/home/meow/Desktop/TSMC18RF/tsmc18rf/../models/spectre/rf018.scs" section=tt_rfesd
include "/home/meow/Desktop/TSMC18RF/tsmc18rf/../models/spectre/rf018.scs" section=tt_bbmvar

// 12bit_50M_SAR/NOR1/schematic
subckt NOR1 A AGND AVDD B VOUT
    M4 (net8 B AVDD AVDD) pch l=180.0n w=800n m=1
    M0 (VOUT A net8 AVDD) pch l=180.0n w=800n m=1
    M3 (VOUT A AGND AGND) nch l=180.0n w=250.0n m=1
    M2 (VOUT B AGND AGND) nch l=180.0n w=250.0n m=1
ends NOR1

// 12bit_50M_SAR/INVX2/schematic
subckt INVX2 IN OUT VDD VSS
    M1 (OUT IN VSS VSS) nch l=180.0n w=500n m=1
    M0 (OUT IN VDD VDD) pch l=180.0n w=1u m=1
ends INVX2

// 12bit_50M_SAR/INVX3/schematic
subckt INVX3 IN OUT VDD VSS
    M1 (OUT IN VSS VSS) nch l=180.0n w=1u m=1
    M0 (OUT IN VDD VDD) pch l=180.0n w=2u m=1
ends INVX3

// 12bit_50M_SAR/INVX1/schematic
subckt INVX1 IN OUT VDD VSS
    M0 (OUT IN VDD VDD) pch l=180.0n w=440.0n m=1
    M1 (OUT IN VSS VSS) nch l=180.0n w=220.0n m=1
ends INVX1

// 12bit_50M_SAR/COM_IAZ/schematic
subckt COM_IAZ AGND AVDD CLK RST VIN VIP VON VOP
    I287 (CLK AGND AVDD net1 net2) NOR1
    V16 (net42 AGND) vsource dc=vcmpre type=dc
    M136 (V3 VB1 AVDD AVDD) pch_mis l=180.0n*L w=2u multi=(10)
    M135 (VON1 net46 V3 AVDD) pch_mis l=180.0n*L w=1.5u multi=(1*F1*L)
    M134 (VOP1 net45 V3 AVDD) pch_mis l=180.0n*L w=1.5u multi=(1*F1*L)
    M133 (net44 CLKFIA AVDD AVDD) pch_mis l=180.0n w=WK multi=(2)
    M132 (net44 CLKFIAB V1 AVDD) pch_mis l=180.0n w=WK1 multi=(2)
    M131 (net43 VIN V1 AVDD) pch_mis l=180.0n w=4u multi=(1*F3)
    M130 (net13637 VIP V1 AVDD) pch_mis l=180.0n w=4u multi=(1*F3)
    M129 (VON1 AGND net43 AVDD) pch_mis l=180.0n w=4u multi=(1*F3)
    M128 (VOP1 AGND net13637 AVDD) pch_mis l=180.0n w=4u multi=(1*F3)
    M97 (net11 CLKB1 AVDD AVDD) pch_mis l=180.0n w=250.0n multi=(1*FM7)
    M81 (net13016 VOP1 net11 AVDD) pch_mis l=180.0n w=2u multi=(1*FSR)
    M80 (net13028 VON1 net11 AVDD) pch_mis l=180.0n w=2u multi=(1*FSR)
    I295 (net3 CLKAZ AVDD AGND) INVX2
    I230 (net5 VOP AVDD AGND) INVX2
    I226 (net4 VON AVDD AGND) INVX2
    M127 (VON1 AVDD net40 AGND) nch_mis l=180.0n w=2u multi=(1*F4)
    M126 (VOP1 AVDD net13605 AGND) nch_mis l=180.0n w=2u multi=(1*F4)
    M125 (net41 CLKFIA V2 AGND) nch_mis l=180.0n w=WK1 multi=(1)
    M124 (net41 CLKFIAB AGND AGND) nch_mis l=180.0n w=WK multi=(1)
    M100 (net40 VIN V2 AGND) nch_mis l=180.0n w=2u multi=(1*F4)
    M99 (net13605 VIP V2 AGND) nch_mis l=180.0n w=2u multi=(1*F4)
    M98 (VON1 net39 V4 AGND) nch_mis l=180.0n*L w=1.5u multi=(1*F2*L)
    M96 (VOP1 net38 V4 AGND) nch_mis l=180.0n*L w=1.5u multi=(1*F2*L)
    M95 (V4 VB2 AGND AGND) nch_mis l=180.0n*L w=1.5u multi=(10)
    I288 (net2 CLKFIA AVDD AGND) INVX3
    I231 (CLKAZ CLKAZB AVDD AGND) INVX3
    I235 (CLKFIA CLKFIAB AVDD AGND) INVX3
    I237 (CLK CLKB AVDD AGND) INVX3
    C13 (AVDD net46) mimcap l=10.36u w=10.36u m=1
    C12 (AVDD net45) mimcap l=10.36u w=10.36u m=1
    C11 (net44 net41) mimcap l=30u w=30u m=csup
    C10 (net39 AGND) mimcap l=10.36u w=10.36u m=1
    C9 (net38 AGND) mimcap l=10.36u w=10.36u m=1
    I148 (CLKB net14) not_gate vlogic_high=1.8 vlogic_low=0 vtrans=0.9 tdel=tlatch trise=10p tfall=10p
    I245 (net14 CLKB1) not_gate vlogic_high=1.8 vlogic_low=0 vtrans=0.9 tdel=10p trise=10p tfall=10p
    V0 (net1 AGND) vsource type=pulse val0=0 val1=vdd period=100n delay=14.1n rise=10p fall=10p width=td-14n
    M166 (VON1 CLKAZ net46 AGND) nch l=180.0n w=WS m=1
    M165 (net45 CLKAZ VOP1 AGND) nch l=180.0n w=WS m=1
    M162 (net42 CLKFIAB VON1 AGND) nch l=180.0n w=WCM m=1
    M161 (VOP1 CLKFIAB net42 AGND) nch l=180.0n w=WCM m=1
    M156 (net38 CLKAZ VOP1 AGND) nch l=180.0n w=WS m=1
    M155 (VON1 CLKAZ net39 AGND) nch l=180.0n w=WS m=1
    M77 (VB2 VB2 AGND AGND) nch l=180.0n w=1u m=1
    M76 (VB1 VB2 AGND AGND) nch l=180.0n w=2u m=1
    M72 (DN DP AGND AGND) nch l=180.0n w=220.0n m=1
    M71 (DP DN AGND AGND) nch l=180.0n w=220.0n m=1
    M70 (DN CLKB1 AGND AGND) nch l=180.0n w=220.0n m=1
    M69 (net13028 CLKB1 AGND AGND) nch l=180.0n w=220.0n m=1
    M68 (DP CLKB1 AGND AGND) nch l=180.0n w=220.0n m=1
    M67 (net13016 CLKB1 AGND AGND) nch l=180.0n w=220.0n m=1
    I223 (AVDD VB2) isource dc=2*IB type=dc
    I294 (RST net3 AVDD AGND) INVX1
    I229 (DP net5 AVDD AGND) INVX1
    I225 (DN net4 AVDD AGND) INVX1
    M164 (net46 CLKAZB VON1 AVDD) pch l=180.0n w=WS m=2
    M163 (VOP1 CLKAZB net45 AVDD) pch l=180.0n w=WS m=2
    M160 (net42 CLKFIA VOP1 AVDD) pch l=180.0n w=WCM m=2
    M159 (VON1 CLKFIA net42 AVDD) pch l=180.0n w=WCM m=2
    M158 (VOP1 CLKAZB net38 AVDD) pch l=180.0n w=WS m=2
    M157 (net39 CLKAZB VON1 AVDD) pch l=180.0n w=WS m=2
    M92 (VB1 VB1 AVDD AVDD) pch l=180.0n w=4u m=1
    M73 (DP DN net13016 AVDD) pch l=180.0n w=220.0n m=2
    M63 (DN DP net13028 AVDD) pch l=180.0n w=220.0n m=2
ends COM_IAZ

// 12bit_50M_SAR/NAND1/schematic
subckt NAND1 A AGND AVDD B VOUT
    M1 (VOUT B AVDD AVDD) pch l=180.0n w=900n m=1
    M0 (VOUT A AVDD AVDD) pch l=180.0n w=900n m=1
    M3 (net1 B AGND AGND) nch l=180.0n w=1u m=1
    M2 (VOUT A net1 AGND) nch l=180.0n w=1u m=1
ends NAND1

// 12bit_50M_SAR/DFF/schematic
subckt DFF CCLK CLK1 COMN D DGND DVDD N P Q
    M10 (P N DVDD DVDD) pch l=180.0n w=500n m=1
    M8 (P Q net3 DVDD) pch l=180.0n w=1u m=1
    M7 (net3 COMN net4 DVDD) pch l=180.0n w=1u m=1
    M6 (net4 CLK1 DVDD DVDD) pch l=180.0n w=1u m=1
    M4 (Q CCLK net2 DVDD) pch l=180.0n w=1u m=1
    M3 (net2 CLK1 DVDD DVDD) pch l=180.0n w=1u m=1
    M0 (CLK1 D DVDD DVDD) pch l=180.0n w=1u m=1
    M11 (P NN DGND DGND) nch l=180.0n w=300n m=1
    M9 (P CLK1 DGND DGND) nch l=180.0n w=250.0n m=2
    M5 (Q CLK1 DGND DGND) nch l=180.0n w=250.0n m=2
    M2 (net1 D DGND DGND) nch l=180.0n w=1u m=1
    M1 (CLK1 CCLK net1 DGND) nch l=180.0n w=1u m=1
    I1 (N DGND DVDD Q net5) NAND1
    I2 (net5 NN DVDD DGND) INVX2
    I0 (P N DVDD DGND) INVX2
ends DFF

// 12bit_50M_SAR/SAR_LOGIC_0716/schematic
subckt SAR_LOGIC_0716 BITN\<13\> BITN\<12\> BITN\<11\> BITN\<10\> BITN\<9\> BITN\<8\> BITN\<7\> BITN\<6\> BITN\<5\> BITN\<4\> BITN\<3\> BITN\<2\> BITN\<1\> BITN\<0\> BITP\<13\> BITP\<12\> BITP\<11\> BITP\<10\> BITP\<9\> BITP\<8\> BITP\<7\> BITP\<6\> BITP\<5\> BITP\<4\> BITP\<3\> BITP\<2\> BITP\<1\> BITP\<0\> CCLK COMN DGND DVDD PRST SET\<0\> SET\<1\> SET\<2\> SET\<3\> SET\<4\> SET\<5\> SET\<6\> SET\<7\> SET\<8\> SET\<9\> SET\<10\> SET\<11\> SET\<12\> SET\<13\>
    I53\<0\> (ST\<0\> DGND DVDD PRST net8\<0\>) NOR1
    I53\<1\> (ST\<1\> DGND DVDD PRST net8\<1\>) NOR1
    I53\<2\> (ST\<2\> DGND DVDD PRST net8\<2\>) NOR1
    I53\<3\> (ST\<3\> DGND DVDD PRST net8\<3\>) NOR1
    I53\<4\> (ST\<4\> DGND DVDD PRST net8\<4\>) NOR1
    I53\<5\> (ST\<5\> DGND DVDD PRST net8\<5\>) NOR1
    I53\<6\> (ST\<6\> DGND DVDD PRST net8\<6\>) NOR1
    I53\<7\> (ST\<7\> DGND DVDD PRST net8\<7\>) NOR1
    I53\<8\> (ST\<8\> DGND DVDD PRST net8\<8\>) NOR1
    I53\<9\> (ST\<9\> DGND DVDD PRST net8\<9\>) NOR1
    I53\<10\> (ST\<10\> DGND DVDD PRST net8\<10\>) NOR1
    I53\<11\> (ST\<11\> DGND DVDD PRST net8\<11\>) NOR1
    I53\<12\> (ST\<12\> DGND DVDD PRST net8\<12\>) NOR1
    I53\<13\> (ST\<13\> DGND DVDD PRST net8\<13\>) NOR1
    I47\<12\> (CCLK ST\<1\> COMN Q\<13\> DGND DVDD BITN\<12\> BITP\<12\> QQ\<12\>) DFF
    I47\<11\> (CCLK ST\<2\> COMN Q\<12\> DGND DVDD BITN\<11\> BITP\<11\> QQ\<11\>) DFF
    I47\<10\> (CCLK ST\<3\> COMN Q\<11\> DGND DVDD BITN\<10\> BITP\<10\> QQ\<10\>) DFF
    I47\<9\> (CCLK ST\<4\> COMN Q\<10\> DGND DVDD BITN\<9\> BITP\<9\> QQ\<9\>) DFF
    I47\<8\> (CCLK ST\<5\> COMN Q\<9\> DGND DVDD BITN\<8\> BITP\<8\> QQ\<8\>) DFF
    I47\<7\> (CCLK ST\<6\> COMN Q\<8\> DGND DVDD BITN\<7\> BITP\<7\> QQ\<7\>) DFF
    I47\<6\> (CCLK ST\<7\> COMN Q\<7\> DGND DVDD BITN\<6\> BITP\<6\> QQ\<6\>) DFF
    I47\<5\> (CCLK ST\<8\> COMN Q\<6\> DGND DVDD BITN\<5\> BITP\<5\> QQ\<5\>) DFF
    I47\<4\> (CCLK ST\<9\> COMN Q\<5\> DGND DVDD BITN\<4\> BITP\<4\> QQ\<4\>) DFF
    I47\<3\> (CCLK ST\<10\> COMN Q\<4\> DGND DVDD BITN\<3\> BITP\<3\> QQ\<3\>) DFF
    I47\<2\> (CCLK ST\<11\> COMN Q\<3\> DGND DVDD BITN\<2\> BITP\<2\> QQ\<2\>) DFF
    I47\<1\> (CCLK ST\<12\> COMN Q\<2\> DGND DVDD BITN\<1\> BITP\<1\> QQ\<1\>) DFF
    I47\<0\> (CCLK ST\<13\> COMN Q\<1\> DGND DVDD BITN\<0\> BITP\<0\> QQ\<0\>) DFF
    I46 (CCLK ST\<0\> COMN PRST_B DGND DVDD BITN\<13\> BITP\<13\> Q\<13\>) DFF
    I51\<12\> (PRST_B DGND DVDD QQ\<12\> net4\<0\>) NAND1
    I51\<11\> (PRST_B DGND DVDD QQ\<11\> net4\<1\>) NAND1
    I51\<10\> (PRST_B DGND DVDD QQ\<10\> net4\<2\>) NAND1
    I51\<9\> (PRST_B DGND DVDD QQ\<9\> net4\<3\>) NAND1
    I51\<8\> (PRST_B DGND DVDD QQ\<8\> net4\<4\>) NAND1
    I51\<7\> (PRST_B DGND DVDD QQ\<7\> net4\<5\>) NAND1
    I51\<6\> (PRST_B DGND DVDD QQ\<6\> net4\<6\>) NAND1
    I51\<5\> (PRST_B DGND DVDD QQ\<5\> net4\<7\>) NAND1
    I51\<4\> (PRST_B DGND DVDD QQ\<4\> net4\<8\>) NAND1
    I51\<3\> (PRST_B DGND DVDD QQ\<3\> net4\<9\>) NAND1
    I51\<2\> (PRST_B DGND DVDD QQ\<2\> net4\<10\>) NAND1
    I51\<1\> (PRST_B DGND DVDD QQ\<1\> net4\<11\>) NAND1
    I63\<13\> (net5\<0\> SET\<0\> DVDD DGND) INVX2
    I63\<12\> (net5\<1\> SET\<1\> DVDD DGND) INVX2
    I63\<11\> (net5\<2\> SET\<2\> DVDD DGND) INVX2
    I63\<10\> (net5\<3\> SET\<3\> DVDD DGND) INVX2
    I63\<9\> (net5\<4\> SET\<4\> DVDD DGND) INVX2
    I63\<8\> (net5\<5\> SET\<5\> DVDD DGND) INVX2
    I63\<7\> (net5\<6\> SET\<6\> DVDD DGND) INVX2
    I63\<6\> (net5\<7\> SET\<7\> DVDD DGND) INVX2
    I63\<5\> (net5\<8\> SET\<8\> DVDD DGND) INVX2
    I63\<4\> (net5\<9\> SET\<9\> DVDD DGND) INVX2
    I63\<3\> (net5\<10\> SET\<10\> DVDD DGND) INVX2
    I63\<2\> (net5\<11\> SET\<11\> DVDD DGND) INVX2
    I63\<1\> (net5\<12\> SET\<12\> DVDD DGND) INVX2
    I63\<0\> (net5\<13\> SET\<13\> DVDD DGND) INVX2
    I52\<12\> (net4\<0\> Q\<12\> DVDD DGND) INVX1
    I52\<11\> (net4\<1\> Q\<11\> DVDD DGND) INVX1
    I52\<10\> (net4\<2\> Q\<10\> DVDD DGND) INVX1
    I52\<9\> (net4\<3\> Q\<9\> DVDD DGND) INVX1
    I52\<8\> (net4\<4\> Q\<8\> DVDD DGND) INVX1
    I52\<7\> (net4\<5\> Q\<7\> DVDD DGND) INVX1
    I52\<6\> (net4\<6\> Q\<6\> DVDD DGND) INVX1
    I52\<5\> (net4\<7\> Q\<5\> DVDD DGND) INVX1
    I52\<4\> (net4\<8\> Q\<4\> DVDD DGND) INVX1
    I52\<3\> (net4\<9\> Q\<3\> DVDD DGND) INVX1
    I52\<2\> (net4\<10\> Q\<2\> DVDD DGND) INVX1
    I52\<1\> (net4\<11\> Q\<1\> DVDD DGND) INVX1
    I56 (net1 net2 DVDD DGND) INVX1
    I57 (net2 PRST_B DVDD DGND) INVX1
    I48 (PRST net1 DVDD DGND) INVX1
    I100\<13\> (net8\<0\> net5\<0\> DVDD DGND) INVX1
    I100\<12\> (net8\<1\> net5\<1\> DVDD DGND) INVX1
    I100\<11\> (net8\<2\> net5\<2\> DVDD DGND) INVX1
    I100\<10\> (net8\<3\> net5\<3\> DVDD DGND) INVX1
    I100\<9\> (net8\<4\> net5\<4\> DVDD DGND) INVX1
    I100\<8\> (net8\<5\> net5\<5\> DVDD DGND) INVX1
    I100\<7\> (net8\<6\> net5\<6\> DVDD DGND) INVX1
    I100\<6\> (net8\<7\> net5\<7\> DVDD DGND) INVX1
    I100\<5\> (net8\<8\> net5\<8\> DVDD DGND) INVX1
    I100\<4\> (net8\<9\> net5\<9\> DVDD DGND) INVX1
    I100\<3\> (net8\<10\> net5\<10\> DVDD DGND) INVX1
    I100\<2\> (net8\<11\> net5\<11\> DVDD DGND) INVX1
    I100\<1\> (net8\<12\> net5\<12\> DVDD DGND) INVX1
    I100\<0\> (net8\<13\> net5\<13\> DVDD DGND) INVX1
ends SAR_LOGIC_0716

// 12bit_50M_SAR/SNDR_DAC/schematic
subckt SNDR_DAC AGND Bit\<11\> Bit\<10\> Bit\<9\> Bit\<8\> Bit\<7\> Bit\<6\> Bit\<5\> Bit\<4\> Bit\<3\> Bit\<2\> Bit\<1\> Bit\<0\> OUT
    E11 (net11 AGND B\<0\> AGND) vcvs gain=1/2048*Vref
    E10 (net10 net11 B\<1\> AGND) vcvs gain=1/1024*Vref
    E9 (net9 net10 B\<2\> AGND) vcvs gain=1/512*Vref
    E8 (net8 net9 B\<3\> AGND) vcvs gain=1/256*Vref
    E7 (net7 net8 B\<4\> AGND) vcvs gain=1/128*Vref
    E6 (net6 net7 B\<5\> AGND) vcvs gain=1/64*Vref
    E5 (net5 net6 B\<6\> AGND) vcvs gain=1/32*Vref
    E4 (net4 net5 B\<7\> AGND) vcvs gain=1/16*Vref
    E3 (net3 net4 B\<8\> AGND) vcvs gain=1/8*Vref
    E2 (net2 net3 B\<9\> AGND) vcvs gain=1/4*Vref
    E1 (net1 net2 B\<10\> AGND) vcvs gain=1/2*Vref
    E0 (OUT net1 B\<11\> AGND) vcvs gain=Vref
    I6\<12\> (net13\<0\> B\<11\>) not_gate vlogic_high=1.8 vlogic_low=0 vtrans=0.9 tdel=10p trise=10p tfall=10p
    I6\<11\> (net13\<1\> B\<10\>) not_gate vlogic_high=1.8 vlogic_low=0 vtrans=0.9 tdel=10p trise=10p tfall=10p
    I6\<10\> (net13\<2\> B\<9\>) not_gate vlogic_high=1.8 vlogic_low=0 vtrans=0.9 tdel=10p trise=10p tfall=10p
    I6\<9\> (net13\<3\> B\<8\>) not_gate vlogic_high=1.8 vlogic_low=0 vtrans=0.9 tdel=10p trise=10p tfall=10p
    I6\<8\> (net13\<4\> B\<7\>) not_gate vlogic_high=1.8 vlogic_low=0 vtrans=0.9 tdel=10p trise=10p tfall=10p
    I6\<7\> (net13\<5\> B\<6\>) not_gate vlogic_high=1.8 vlogic_low=0 vtrans=0.9 tdel=10p trise=10p tfall=10p
    I6\<6\> (net13\<6\> B\<5\>) not_gate vlogic_high=1.8 vlogic_low=0 vtrans=0.9 tdel=10p trise=10p tfall=10p
    I6\<5\> (net13\<7\> B\<4\>) not_gate vlogic_high=1.8 vlogic_low=0 vtrans=0.9 tdel=10p trise=10p tfall=10p
    I6\<4\> (net13\<8\> B\<3\>) not_gate vlogic_high=1.8 vlogic_low=0 vtrans=0.9 tdel=10p trise=10p tfall=10p
    I6\<3\> (net13\<9\> B\<2\>) not_gate vlogic_high=1.8 vlogic_low=0 vtrans=0.9 tdel=10p trise=10p tfall=10p
    I6\<2\> (net13\<10\> B\<1\>) not_gate vlogic_high=1.8 vlogic_low=0 vtrans=0.9 tdel=10p trise=10p tfall=10p
    I6\<1\> (net13\<11\> B\<0\>) not_gate vlogic_high=1.8 vlogic_low=0 vtrans=0.9 tdel=10p trise=10p tfall=10p
    I\<12\> (Bit\<11\> net13\<0\>) not_gate vlogic_high=1.8 vlogic_low=0 vtrans=0.9 tdel=10p trise=10p tfall=10p
    I\<11\> (Bit\<10\> net13\<1\>) not_gate vlogic_high=1.8 vlogic_low=0 vtrans=0.9 tdel=10p trise=10p tfall=10p
    I\<10\> (Bit\<9\> net13\<2\>) not_gate vlogic_high=1.8 vlogic_low=0 vtrans=0.9 tdel=10p trise=10p tfall=10p
    I\<9\> (Bit\<8\> net13\<3\>) not_gate vlogic_high=1.8 vlogic_low=0 vtrans=0.9 tdel=10p trise=10p tfall=10p
    I\<8\> (Bit\<7\> net13\<4\>) not_gate vlogic_high=1.8 vlogic_low=0 vtrans=0.9 tdel=10p trise=10p tfall=10p
    I\<7\> (Bit\<6\> net13\<5\>) not_gate vlogic_high=1.8 vlogic_low=0 vtrans=0.9 tdel=10p trise=10p tfall=10p
    I\<6\> (Bit\<5\> net13\<6\>) not_gate vlogic_high=1.8 vlogic_low=0 vtrans=0.9 tdel=10p trise=10p tfall=10p
    I\<5\> (Bit\<4\> net13\<7\>) not_gate vlogic_high=1.8 vlogic_low=0 vtrans=0.9 tdel=10p trise=10p tfall=10p
    I\<4\> (Bit\<3\> net13\<8\>) not_gate vlogic_high=1.8 vlogic_low=0 vtrans=0.9 tdel=10p trise=10p tfall=10p
    I\<3\> (Bit\<2\> net13\<9\>) not_gate vlogic_high=1.8 vlogic_low=0 vtrans=0.9 tdel=10p trise=10p tfall=10p
    I\<2\> (Bit\<1\> net13\<10\>) not_gate vlogic_high=1.8 vlogic_low=0 vtrans=0.9 tdel=10p trise=10p tfall=10p
    I\<1\> (Bit\<0\> net13\<11\>) not_gate vlogic_high=1.8 vlogic_low=0 vtrans=0.9 tdel=10p trise=10p tfall=10p
ends SNDR_DAC

// 12bit_50M_SAR/CDAC_0716/schematic
subckt CDAC_0716 BITD\<1\> BITD\<2\> BITD\<3\> BITD\<4\> BITD\<5\> BITD\<6\> BITD\<7\> BITD\<8\> BITD\<9\> BITD\<10\> BITD\<11\> BITD\<12\> BITD\<13\> BITU\<1\> BITU\<2\> BITU\<3\> BITU\<4\> BITU\<5\> BITU\<6\> BITU\<7\> BITU\<8\> BITU\<9\> BITU\<10\> BITU\<11\> BITU\<12\> BITU\<13\> N P
    C153 (N BITU\<8\>) capacitor c=1.000000000*C
    C154 (N BITU\<12\>) capacitor c=7.997406163*C
    C155 (N BITU\<11\>) capacitor c=3.999110064*C
    C156 (N BITU\<13\>) capacitor c=16.003462645*C
    C157 (net4 BITU\<4\>) capacitor c=6.000000000*C
    C249 (N BITU\<9\>) capacitor c=2.000000000*C
    C248 (P BITD\<9\>) capacitor c=2.000000000*C
    C152 (N BITU\<10\>) capacitor c=2.000000000*C
    C141 (P BITD\<12\>) capacitor c=8.001169277*C
    C149 (net4 BITU\<5\>) capacitor c=10.000000000*C
    C144 (net3 P) capacitor c=1.000000000*C
    C147 (net4 BITU\<2\>) capacitor c=2.000000000*C
    C143 (P BITD\<13\>) capacitor c=15.998998807*C
    C146 (net4 BITU\<1\>) capacitor c=1.000000000*C
    C139 (P BITD\<10\>) capacitor c=2.000000000*C
    C151 (net4 BITU\<7\>) capacitor c=24.000000000*C
    C138 (net3 BITD\<7\>) capacitor c=24.000000000*C
    C150 (net4 BITU\<6\>) capacitor c=16.000000000*C
    C145 (net4 N) capacitor c=1.000000000*C
    C142 (P BITD\<11\>) capacitor c=3.998076619*C
    C148 (net4 BITU\<3\>) capacitor c=4.000000000*C
    C140 (P BITD\<8\>) capacitor c=1.000000000*C
    C136 (net3 BITD\<5\>) capacitor c=10.000000000*C
    C137 (net3 BITD\<6\>) capacitor c=16.000000000*C
    C132 (net3 BITD\<4\>) capacitor c=6.000000000*C
    C135 (net3 BITD\<3\>) capacitor c=4.000000000*C
    C134 (net3 BITD\<2\>) capacitor c=2.000000000*C
    C133 (net3 BITD\<1\>) capacitor c=1.000000000*C
ends CDAC_0716

// 12bit_50M_SAR/SYNC_asnyc/schematic
subckt SYNC_asnyc CCLK CLK CLK00 COMN COMP DEC_N DGND DVDD SET\<12\>
    I163 (net11 PCLK DVDD DGND) INVX1
    I165 (VALID net9 DVDD DGND) INVX1
    I110 (PCLK net1 DVDD DGND) INVX1
    I166 (net12 net2 DVDD DGND) INVX1
    I167 (SET\<12\> net6 DVDD DGND) INVX1
    I154 (A VALID) not_gate vlogic_high=vdd vlogic_low=0 vtrans=vdd/2 tdel=500p trise=10p tfall=10p
    I158 (net3 CCLK) not_gate vlogic_high=1.8 vlogic_low=0 vtrans=0.9 tdel=10p trise=10p tfall=10p
    I157 (PCLK net3) not_gate vlogic_high=1.8 vlogic_low=0 vtrans=0.9 tdel=tdac trise=10p tfall=10p
    I150 (COMN DGND DVDD COMP A) NOR1
    I149 (COMN DGND DVDD CLKB net5) NOR1
    I153 (net9 DGND DVDD net2 net11) NAND1
    I112 (net6 DGND DVDD CLK00 net12) NAND1
    I164 (net1 CLK DVDD DGND) INVX3
    I156 (net5 DEC_N DVDD DGND) INVX3
    I148 (CLK CLKB DVDD DGND) INVX3
ends SYNC_asnyc

// 12bit_50M_SAR/BS/schematic
subckt BS AGND AVDD CLK VIN VOUT
    I1 (CLK CLKB AVDD AGND) INVX3
    M32 (net2 CLKB AGND AGND) nch l=180.0n w=8u m=1
    M33 (VIN X net3 AGND) nch l=180.0n w=9u m=1
    M34 (net3 CLKB AGND AGND) nch l=180.0n w=1u m=1
    M37 (net1 CLK net3 AGND) nch l=180.0n w=1u m=1
    M38 (net1 X net3 AGND) nch l=180.0n w=1u m=1
    M39 (X AVDD net2 AGND) nch l=180.0n w=8u m=1
    M30 (VOUT X VIN AGND) nch l=180.0n w=9u m=1
    M31 (X net1 net4 net4) pch l=180.0n w=1u m=1
    M35 (net4 X AVDD net4) pch l=180.0n w=1u m=1
    M36 (net1 CLK AVDD AVDD) pch l=180.0n w=1u m=1
    C0 (net4 net3) mimcap l=30u w=30u m=1
ends BS

// 12bit_50M_SAR/test_12bit50MSAR_AMS_final_0716/schematic
I28 (AGND AVDD CLK RST N P COMN COMP) COM_IAZ
I15 (BITN\<13\> BITN\<12\> BITN\<11\> BITN\<10\> BITN\<9\> BITN\<8\> BITN\<7\> BITN\<6\> BITN\<5\> BITN\<4\> BITN\<3\> BITN\<2\> BITN\<1\> BITN\<0\> BITP\<13\> BITP\<12\> BITP\<11\> BITP\<10\> BITP\<9\> BITP\<8\> BITP\<7\> BITP\<6\> BITP\<5\> BITP\<4\> BITP\<3\> BITP\<2\> BITP\<1\> BITP\<0\> CCLK DEC_N DGND DVDD PRST SET\<0\> SET\<1\> SET\<2\> SET\<3\> SET\<4\> SET\<5\> SET\<6\> SET\<7\> SET\<8\> SET\<9\> SET\<10\> SET\<11\> SET\<12\> SET\<13\>) SAR_LOGIC_0716
I34 (AGND Bit\<11\> Bit\<10\> Bit\<9\> Bit\<8\> Bit\<7\> Bit\<6\> Bit\<5\> Bit\<4\> Bit\<3\> Bit\<2\> Bit\<1\> Bit\<0\> OUT) SNDR_DAC
I1 (BITD\<1\> BITD\<2\> BITD\<3\> BITD\<4\> BITD\<5\> BITD\<6\> BITD\<7\> BITD\<8\> BITD\<9\> BITD\<10\> BITD\<11\> BITD\<12\> BITD\<13\> BITU\<1\> BITU\<2\> BITU\<3\> BITU\<4\> BITU\<5\> BITU\<6\> BITU\<7\> BITU\<8\> BITU\<9\> BITU\<10\> BITU\<11\> BITU\<12\> BITU\<13\> N P) CDAC_0716
V26 (AGND 0) vsource dc=0 type=dc
V27 (DGND 0) vsource dc=0 type=dc
V28 (VCM AGND) vsource dc=vdd/2 type=dc
V29 (VREFP AGND) vsource dc=1.8 type=dc
V30 (VREFN AGND) vsource dc=0 type=dc
V31 (DVDD DGND) vsource dc=vdd type=dc
V34 (AVDD AGND) vsource dc=vdd type=dc
V7 (RST AGND) vsource type=pulse val0=0 val1=vdd period=100n delay=100p rise=10p fall=10p width=td
V48 (CAL_START AGND) vsource type=pulse val0=0 val1=vdd period=150u delay=5n rise=10p fall=10p width=2n
V13 (PRST AGND) vsource type=pulse val0=0 val1=vdd period=100n delay=-2n rise=10p fall=10p width=20n
V10 (RST1 AGND) vsource type=pulse val0=0 val1=vdd period=100n delay=100p rise=10p fall=10p width=14n
V8 (SOUT AGND) vsource type=pulse val0=0 val1=vdd period=100n delay=-2n rise=10p fall=10p width=2n
V40 (CLK00 AGND) vsource type=pulse val0=0 val1=vdd period=100n delay=20n rise=10p fall=10p width=79n
V50 (CAL_CLK AGND) vsource type=pulse val0=0 val1=vdd period=10n delay=10p rise=10p fall=10p width=5n
V41 (CLK0 AGND) vsource type=pulse val0=vdd val1=0 period=100n delay=13n rise=10p fall=10p width=5n
V49 (CAL_RST AGND) vsource type=pulse val0=0 val1=vdd period=150u delay=1n rise=10p fall=10p width=2n
V36 (VIN1 VCM) vsource type=sine ampl=va freq=N/M*10M
V35 (VCM VIP1) vsource type=sine ampl=va freq=N/M*10M
C0 (VIN AGND) mimcap l=30u w=30u m=2
C1 (VIP AGND) mimcap l=30u w=30u m=2
I91 (CCLK CLK_SAR CLK00 COMN COMP DEC_N DGND DVDD SET\<13\>) SYNC_asnyc
I26\<13\> (net1\<0\> BN\<13\>) not_gate vlogic_high=vdd vlogic_low=0 vtrans=vdd/2 tdel=10p trise=10p tfall=10p
I26\<12\> (net1\<1\> BN\<12\>) not_gate vlogic_high=vdd vlogic_low=0 vtrans=vdd/2 tdel=10p trise=10p tfall=10p
I26\<11\> (net1\<2\> BN\<11\>) not_gate vlogic_high=vdd vlogic_low=0 vtrans=vdd/2 tdel=10p trise=10p tfall=10p
I26\<10\> (net1\<3\> BN\<10\>) not_gate vlogic_high=vdd vlogic_low=0 vtrans=vdd/2 tdel=10p trise=10p tfall=10p
I26\<9\> (net1\<4\> BN\<9\>) not_gate vlogic_high=vdd vlogic_low=0 vtrans=vdd/2 tdel=10p trise=10p tfall=10p
I26\<8\> (net1\<5\> BN\<8\>) not_gate vlogic_high=vdd vlogic_low=0 vtrans=vdd/2 tdel=10p trise=10p tfall=10p
I26\<7\> (net1\<6\> BN\<7\>) not_gate vlogic_high=vdd vlogic_low=0 vtrans=vdd/2 tdel=10p trise=10p tfall=10p
I26\<6\> (net1\<7\> BN\<6\>) not_gate vlogic_high=vdd vlogic_low=0 vtrans=vdd/2 tdel=10p trise=10p tfall=10p
I26\<5\> (net1\<8\> BN\<5\>) not_gate vlogic_high=vdd vlogic_low=0 vtrans=vdd/2 tdel=10p trise=10p tfall=10p
I26\<4\> (net1\<9\> BN\<4\>) not_gate vlogic_high=vdd vlogic_low=0 vtrans=vdd/2 tdel=10p trise=10p tfall=10p
I26\<3\> (net1\<10\> BN\<3\>) not_gate vlogic_high=vdd vlogic_low=0 vtrans=vdd/2 tdel=10p trise=10p tfall=10p
I26\<2\> (net1\<11\> BN\<2\>) not_gate vlogic_high=vdd vlogic_low=0 vtrans=vdd/2 tdel=10p trise=10p tfall=10p
I26\<1\> (net1\<12\> BN\<1\>) not_gate vlogic_high=vdd vlogic_low=0 vtrans=vdd/2 tdel=10p trise=10p tfall=10p
I26\<0\> (net1\<13\> BN\<0\>) not_gate vlogic_high=vdd vlogic_low=0 vtrans=vdd/2 tdel=10p trise=10p tfall=10p
I51\<13\> (BITN\<13\> net1\<0\>) not_gate vlogic_high=vdd vlogic_low=0 vtrans=vdd/2 tdel=10p trise=10p tfall=10p
I51\<12\> (BITN\<12\> net1\<1\>) not_gate vlogic_high=vdd vlogic_low=0 vtrans=vdd/2 tdel=10p trise=10p tfall=10p
I51\<11\> (BITN\<11\> net1\<2\>) not_gate vlogic_high=vdd vlogic_low=0 vtrans=vdd/2 tdel=10p trise=10p tfall=10p
I51\<10\> (BITN\<10\> net1\<3\>) not_gate vlogic_high=vdd vlogic_low=0 vtrans=vdd/2 tdel=10p trise=10p tfall=10p
I51\<9\> (BITN\<9\> net1\<4\>) not_gate vlogic_high=vdd vlogic_low=0 vtrans=vdd/2 tdel=10p trise=10p tfall=10p
I51\<8\> (BITN\<8\> net1\<5\>) not_gate vlogic_high=vdd vlogic_low=0 vtrans=vdd/2 tdel=10p trise=10p tfall=10p
I51\<7\> (BITN\<7\> net1\<6\>) not_gate vlogic_high=vdd vlogic_low=0 vtrans=vdd/2 tdel=10p trise=10p tfall=10p
I51\<6\> (BITN\<6\> net1\<7\>) not_gate vlogic_high=vdd vlogic_low=0 vtrans=vdd/2 tdel=10p trise=10p tfall=10p
I51\<5\> (BITN\<5\> net1\<8\>) not_gate vlogic_high=vdd vlogic_low=0 vtrans=vdd/2 tdel=10p trise=10p tfall=10p
I51\<4\> (BITN\<4\> net1\<9\>) not_gate vlogic_high=vdd vlogic_low=0 vtrans=vdd/2 tdel=10p trise=10p tfall=10p
I51\<3\> (BITN\<3\> net1\<10\>) not_gate vlogic_high=vdd vlogic_low=0 vtrans=vdd/2 tdel=10p trise=10p tfall=10p
I51\<2\> (BITN\<2\> net1\<11\>) not_gate vlogic_high=vdd vlogic_low=0 vtrans=vdd/2 tdel=10p trise=10p tfall=10p
I51\<1\> (BITN\<1\> net1\<12\>) not_gate vlogic_high=vdd vlogic_low=0 vtrans=vdd/2 tdel=10p trise=10p tfall=10p
I51\<0\> (BITN\<0\> net1\<13\>) not_gate vlogic_high=vdd vlogic_low=0 vtrans=vdd/2 tdel=10p trise=10p tfall=10p
I93\<13\> (net2\<0\> BP\<13\>) not_gate vlogic_high=vdd vlogic_low=0 vtrans=vdd/2 tdel=10p trise=10p tfall=10p
I93\<12\> (net2\<1\> BP\<12\>) not_gate vlogic_high=vdd vlogic_low=0 vtrans=vdd/2 tdel=10p trise=10p tfall=10p
I93\<11\> (net2\<2\> BP\<11\>) not_gate vlogic_high=vdd vlogic_low=0 vtrans=vdd/2 tdel=10p trise=10p tfall=10p
I93\<10\> (net2\<3\> BP\<10\>) not_gate vlogic_high=vdd vlogic_low=0 vtrans=vdd/2 tdel=10p trise=10p tfall=10p
I93\<9\> (net2\<4\> BP\<9\>) not_gate vlogic_high=vdd vlogic_low=0 vtrans=vdd/2 tdel=10p trise=10p tfall=10p
I93\<8\> (net2\<5\> BP\<8\>) not_gate vlogic_high=vdd vlogic_low=0 vtrans=vdd/2 tdel=10p trise=10p tfall=10p
I93\<7\> (net2\<6\> BP\<7\>) not_gate vlogic_high=vdd vlogic_low=0 vtrans=vdd/2 tdel=10p trise=10p tfall=10p
I93\<6\> (net2\<7\> BP\<6\>) not_gate vlogic_high=vdd vlogic_low=0 vtrans=vdd/2 tdel=10p trise=10p tfall=10p
I93\<5\> (net2\<8\> BP\<5\>) not_gate vlogic_high=vdd vlogic_low=0 vtrans=vdd/2 tdel=10p trise=10p tfall=10p
I93\<4\> (net2\<9\> BP\<4\>) not_gate vlogic_high=vdd vlogic_low=0 vtrans=vdd/2 tdel=10p trise=10p tfall=10p
I93\<3\> (net2\<10\> BP\<3\>) not_gate vlogic_high=vdd vlogic_low=0 vtrans=vdd/2 tdel=10p trise=10p tfall=10p
I93\<2\> (net2\<11\> BP\<2\>) not_gate vlogic_high=vdd vlogic_low=0 vtrans=vdd/2 tdel=10p trise=10p tfall=10p
I93\<1\> (net2\<12\> BP\<1\>) not_gate vlogic_high=vdd vlogic_low=0 vtrans=vdd/2 tdel=10p trise=10p tfall=10p
I93\<0\> (net2\<13\> BP\<0\>) not_gate vlogic_high=vdd vlogic_low=0 vtrans=vdd/2 tdel=10p trise=10p tfall=10p
I0\<13\> (BITP\<13\> net2\<0\>) not_gate vlogic_high=vdd vlogic_low=0 vtrans=vdd/2 tdel=10p trise=10p tfall=10p
I0\<12\> (BITP\<12\> net2\<1\>) not_gate vlogic_high=vdd vlogic_low=0 vtrans=vdd/2 tdel=10p trise=10p tfall=10p
I0\<11\> (BITP\<11\> net2\<2\>) not_gate vlogic_high=vdd vlogic_low=0 vtrans=vdd/2 tdel=10p trise=10p tfall=10p
I0\<10\> (BITP\<10\> net2\<3\>) not_gate vlogic_high=vdd vlogic_low=0 vtrans=vdd/2 tdel=10p trise=10p tfall=10p
I0\<9\> (BITP\<9\> net2\<4\>) not_gate vlogic_high=vdd vlogic_low=0 vtrans=vdd/2 tdel=10p trise=10p tfall=10p
I0\<8\> (BITP\<8\> net2\<5\>) not_gate vlogic_high=vdd vlogic_low=0 vtrans=vdd/2 tdel=10p trise=10p tfall=10p
I0\<7\> (BITP\<7\> net2\<6\>) not_gate vlogic_high=vdd vlogic_low=0 vtrans=vdd/2 tdel=10p trise=10p tfall=10p
I0\<6\> (BITP\<6\> net2\<7\>) not_gate vlogic_high=vdd vlogic_low=0 vtrans=vdd/2 tdel=10p trise=10p tfall=10p
I0\<5\> (BITP\<5\> net2\<8\>) not_gate vlogic_high=vdd vlogic_low=0 vtrans=vdd/2 tdel=10p trise=10p tfall=10p
I0\<4\> (BITP\<4\> net2\<9\>) not_gate vlogic_high=vdd vlogic_low=0 vtrans=vdd/2 tdel=10p trise=10p tfall=10p
I0\<3\> (BITP\<3\> net2\<10\>) not_gate vlogic_high=vdd vlogic_low=0 vtrans=vdd/2 tdel=10p trise=10p tfall=10p
I0\<2\> (BITP\<2\> net2\<11\>) not_gate vlogic_high=vdd vlogic_low=0 vtrans=vdd/2 tdel=10p trise=10p tfall=10p
I0\<1\> (BITP\<1\> net2\<12\>) not_gate vlogic_high=vdd vlogic_low=0 vtrans=vdd/2 tdel=10p trise=10p tfall=10p
I0\<0\> (BITP\<0\> net2\<13\>) not_gate vlogic_high=vdd vlogic_low=0 vtrans=vdd/2 tdel=10p trise=10p tfall=10p
I94 (AGND AVDD BITD\<1\> BITD\<2\> BITD\<3\> BITD\<4\> BITD\<5\> BITD\<6\> BITD\<7\> BITD\<8\> BITD\<9\> BITD\<10\> BITD\<11\> BITD\<12\> BITD\<13\> BITN\<0\> BITN\<1\> BITN\<2\> BITN\<3\> BITN\<4\> BITN\<5\> BITN\<6\> BITN\<7\> BITN\<8\> BITN\<9\> BITN\<10\> BITN\<11\> BITN\<12\> BITN\<13\> BITP\<0\> BITP\<1\> BITP\<2\> BITP\<3\> BITP\<4\> BITP\<5\> BITP\<6\> BITP\<7\> BITP\<8\> BITP\<9\> BITP\<10\> BITP\<11\> BITP\<12\> BITP\<13\> BITU\<1\> BITU\<2\> BITU\<3\> BITU\<4\> BITU\<5\> BITU\<6\> BITU\<7\> BITU\<8\> BITU\<9\> BITU\<10\> BITU\<11\> BITU\<12\> BITU\<13\> N P RST RST1 SET\<0\> SET\<1\> SET\<2\> SET\<3\> SET\<4\> SET\<5\> SET\<6\> SET\<7\> SET\<8\> SET\<9\> SET\<10\> SET\<11\> SET\<12\> VCM VIN VIP VREFN VREFP BITD_CAL\<0\> BITD_CAL\<1\> BITD_CAL\<2\> BITD_CAL\<3\> BITD_CAL\<4\> BITD_CAL\<5\> BITD_CAL\<6\> BITD_CAL\<7\> BITD_CAL\<8\> BITD_CAL\<9\> BITD_CAL\<10\> BITD_CAL\<11\> BITD_CAL\<12\> BITU_CAL\<0\> BITU_CAL\<1\> BITU_CAL\<2\> BITU_CAL\<3\> BITU_CAL\<4\> BITU_CAL\<5\> BITU_CAL\<6\> BITU_CAL\<7\> BITU_CAL\<8\> BITU_CAL\<9\> BITU_CAL\<10\> BITU_CAL\<11\> BITU_CAL\<12\> CAL CAL_CLK) SWITCH_CAL RON_SAMPLE=5 RON_REF=10 RON_TOP=5 ROFF=1e+15 VSMOOTH=0.01 TD_RSTT=2e-10 TD_RST11=2e-10 TCLK_EDGE=1e-11 NORMAL_REF_SWAP=1
I55 (AGND AVDD CLK0 VIP1 VIP) BS
I54 (AGND AVDD CLK0 VIN1 VIN) BS
I95 (Bit\<11\> Bit\<10\> Bit\<9\> Bit\<8\> Bit\<7\> Bit\<6\> Bit\<5\> Bit\<4\> Bit\<3\> Bit\<2\> Bit\<1\> Bit\<0\> BP\<0\> BP\<1\> BP\<2\> BP\<3\> BP\<4\> BP\<5\> BP\<6\> BP\<7\> BP\<8\> BP\<9\> BP\<10\> BP\<11\> BP\<12\> BP\<13\> DGND DVDD SOUT COMP COMN RST1 CAL_RST CLK_SAR CLK00 CLK BITD_CAL\<0\> BITD_CAL\<1\> BITD_CAL\<2\> BITD_CAL\<3\> BITD_CAL\<4\> BITD_CAL\<5\> BITD_CAL\<6\> BITD_CAL\<7\> BITD_CAL\<8\> BITD_CAL\<9\> BITD_CAL\<10\> BITD_CAL\<11\> BITD_CAL\<12\> BITU_CAL\<0\> BITU_CAL\<1\> BITU_CAL\<2\> BITU_CAL\<3\> BITU_CAL\<4\> BITU_CAL\<5\> BITU_CAL\<6\> BITU_CAL\<7\> BITU_CAL\<8\> BITU_CAL\<9\> BITU_CAL\<10\> BITU_CAL\<11\> BITU_CAL\<12\> CAL DONE ERR CAL_CLK) DEC_CAL_PHY VTH_FRACTION=0.5 TD=0 TR=2e-11 TF=2e-11 TD_CAL=2e-10 TD_CMP_CAL=2e-09 CMP_SWAP=1 CMP_VALID_FRACTION=0.2 MAX_INVALID=3 ZERO_ON_INVALID_PHASE0=1 ZERO_ON_INVALID_PHASE1=1 FIRST_INVERT=0 RAW_INVERT=0 WEIGHT_TOL=0.25 UPDATE_DEADBAND_LSB=0 HIGH_WEIGHT_UPDATE_DEADBAND_LSB=0 APPLY_BIN_MIDPOINT=0 AUTO_BIN_MIDPOINT=0 NORMALIZE_REDUNDANT_RANGE=0 DEBUG=1 FRAC_BITS=6 AVG_PAIRS_LOG2=0 AVG_LOG2=3 CAL_C7=0 CAL_BYPASS=1 REMOVE_REDUNDANCY_OFFSET=1
simulatorOptions options temp=27.0 homotopy=all limit=delta gmethod=dev dptran_gmethod=dev try_fast_op=yes
dcOp dc homotopy=gmin
tran tran stop=14.1u cmin=1.23364538742384a strobeoutput=all
save OUT SOUT CAL DONE ERR BP\<0\> BP\<1\> BP\<2\> BP\<3\> BP\<4\> BP\<5\> BP\<6\> BP\<7\> BP\<8\> BP\<9\> BP\<10\> BP\<11\> BP\<12\> BP\<13\> Bit\<0\> Bit\<1\> Bit\<2\> Bit\<3\> Bit\<4\> Bit\<5\> Bit\<6\> Bit\<7\> Bit\<8\> Bit\<9\> Bit\<10\> Bit\<11\>
saveOptions options save=selected currents=selected
ahdl_include "/opt/cadence/IC618/tools/dfII/samples/artist/ahdlLib/not_gate/veriloga/veriloga.va"
ahdl_include "SWITCH_CAL_original.va"
ahdl_include "DEC_CAL_PHY_FRAME_SYNC.va"
