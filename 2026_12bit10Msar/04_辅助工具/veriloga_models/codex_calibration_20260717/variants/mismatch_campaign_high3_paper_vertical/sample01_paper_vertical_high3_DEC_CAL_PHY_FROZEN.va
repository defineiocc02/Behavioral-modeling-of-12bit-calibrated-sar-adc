// TEST-ONLY FROZEN HUANG WEIGHTS.
// Source calibration: D:\ReedZhao\Document\Obsidian\日常\10_项目区\2026_12bit10Msar\04_辅助工具\veriloga_models\codex_calibration_20260717\results\mismatch_campaign_high3_paper_vertical\sample01_paper_vertical_high3\calibration_avg1\calibration_summary.json
// Do not deploy this file as the foreground calibration implementation.
// Corrected physical closed-loop foreground calibration and decoder for
// test_12bit50MSAR_AMS_final_0716.
//
// The calibration result is obtained only from the external CDAC and the
// external comparator outputs COMP/COMN.  No ACT_W* plant parameters are used.
//
// Internal calibration/weight indices follow conversion-stage order:
//   stage 0 -> physical 13 = 16C
//   stage 1 -> physical 12 = 8C
//   stage 2 -> physical 11 = 4C
//   stage 3 -> physical 10 = 2C
//   stage 4 -> physical 9  = 2C redundant
//   stage 5 -> physical 8  = 1C
//   ...
//   stage 12 -> physical 1
//   stage 13 -> terminal comparator-only decision.
//
// The existing 0716 PN buffer presents BP in physical/SAR numbering:
// BP<13> is the first/MSB decision and BP<0> is the terminal decision.  The
// normal decoder therefore reverses BP explicitly when loading r0..r13.
//
// Huang foreground calibration synchronized to the 100 ns converter frame:
//   * C1..C7 form this CDAC's non-binary six-bit calibration DAC.  Its
//     half-weight sequence is 24,16,10,6,4,2,1 and its range is 0..63;
//   * exactly one mirrored-side measurement is completed per valid frame;
//   * C8, C9 and the redundant direct 2C branch CR are measured first;
//   * C10, C11 and C12 are then measured against exact nominal walls made from
//     the two calibrated 2C branches, so MSB mismatch is corrected inside the
//     256-LSB physical overlap supplied by the redundant branch;
//   * every target is measured in both differential directions;
//   * D+ and D- are combined as (D+ - D-)/2, following (4.19);
//   * the number of positive/negative pairs is configurable.  One pair is
//     sufficient for behavioral closure; 32 pairs reproduce the paper's
//     64-conversion statistical setting.
//   * CAL_CLK supplies precharge/evaluate cycles only after RST1 falls; samples
//     during the next RST/IAZ interval are explicitly blocked.
//
// Every decision is produced by the external physical CDAC and the external
// COMP/COMN comparator.  The model contains no hidden "actual weight" input.

`include "constants.vams"
`include "disciplines.vams"

module DEC_CAL_PHY (
    Bit, BP, DGND, DVDD, SOUT,
    COMP, COMN, RST1, CAL_RST,
    CLK_SAR, CLK00, CLK,
    BITD_CAL, BITU_CAL,
    CAL, DONE, ERR, CAL_CLK
);

    output [11:0] Bit;
    input  [0:13] BP;
    inout  DGND, DVDD;
    input  SOUT;
    input  COMP, COMN;
    input  RST1, CAL_RST;
    input  CLK_SAR, CLK00;
    input  CAL_CLK;
    output CLK;
    output [0:12] BITD_CAL, BITU_CAL;
    output CAL, DONE, ERR;

    electrical [11:0] Bit;
    electrical [0:13] BP;
    electrical DGND, DVDD;
    electrical SOUT;
    electrical COMP, COMN;
    electrical RST1, CAL_RST, CAL_CLK;
    electrical CLK_SAR, CLK00, CLK;
    electrical [0:12] BITD_CAL, BITU_CAL;
    electrical CAL, DONE, ERR;

    // Logic/interface parameters.
    parameter real VTH_FRACTION = 0.5 from (0.0:1.0);
    parameter real TD = 0.0 from [0.0:inf);
    parameter real TR = 20p from (0.0:inf);
    parameter real TF = 20p from (0.0:inf);
    // Delays the CAL_CLK precharge-to-residue bottom-plate transition.
    parameter real TD_CAL = 200p from [0.0:inf);
    // CAL_CLK first releases/switches the CDAC.  The real comparator clock is
    // delayed so that the external CDAC has time to settle before evaluation.
    parameter real TD_CMP_CAL = 2n from [0.0:inf);

    // StrongArm polarity convention.  Raw convention first assumes
    // COMP falling below COMN means P is higher than N.  The existing
    // schematic CDF/netlist passes CMP_SWAP=1, and in this project that
    // value must flip the raw convention to match the real COM_IAZ polarity.
    parameter integer CMP_SWAP = 1;
    parameter real CMP_VALID_FRACTION = 0.20 from (0.0:1.0);
    parameter integer MAX_INVALID = 3 from [0:inf);
    // Exact redundant walls and exact SAR-search hits can intentionally
    // produce a near-zero comparator residue.  Treat repeated invalid outputs
    // as a zero-residue event instead of failing calibration immediately.
    parameter integer ZERO_ON_INVALID_PHASE0 = 1 from [0:1];
    parameter integer ZERO_ON_INVALID_PHASE1 = 1 from [0:1];

    // Existing raw-code polarity controls retained from DEC_CAL v2.
    parameter integer FIRST_INVERT = 0;
    parameter integer RAW_INVERT = 0;

    // Candidate-weight safety check and diagnostics.  This check can only
    // reject an implausible run; it never changes a measured weight.
    parameter real WEIGHT_TOL = 0.25 from (0.0:1.0);
    // Deprecated CDF compatibility parameters.  Huang calibration stores the
    // measured average directly; no nominal deadband or bin midpoint is used.
    parameter real UPDATE_DEADBAND_LSB = 2.0 from [0.0:inf);
    parameter real HIGH_WEIGHT_UPDATE_DEADBAND_LSB = 1.0 from [0.0:inf);
    parameter integer APPLY_BIN_MIDPOINT = 0 from [0:1];
    parameter integer AUTO_BIN_MIDPOINT = 1 from [0:1];
    parameter integer DEBUG = 1;

    // Six fractional bits can preserve a 32-pair average.  AVG_PAIRS_LOG2=0
    // selects the fast one-pair behavioral check; AVG_PAIRS_LOG2=5 selects
    // the paper's 64-conversion statistical setting.
    parameter integer FRAC_BITS = 6 from [0:8];
    parameter integer AVG_PAIRS_LOG2 = 0 from [0:8];
    // Legacy parameter kept only so old CDF/netlists with AVG_LOG2 still parse.
    parameter integer AVG_LOG2 = 3 from [0:8];

    // Deprecated compatibility parameter.  C1..C7 always act as the six-bit
    // calibration DAC; they are not themselves foreground-calibrated.
    parameter integer CAL_C7 = 0 from [0:1];

    // Static bypass for comparison runs.  No extra schematic pin is required:
    // nominal Q-format weights are loaded and DONE is asserted at startup.
    parameter integer CAL_BYPASS = 0 from [0:1];
    // Map the complete calibrated non-binary range back to the 12-bit output
    // range.  This preserves the original near-full-scale input range even
    // though the redundant raw weights sum to more than 4095.
    parameter integer NORMALIZE_REDUNDANT_RANGE = 1 from [0:1];
    // Legacy offset-only mode.  It centers the redundant range but clips both
    // ends when the input uses the original full-scale amplitude.  It is used
    // only when NORMALIZE_REDUNDANT_RANGE=0.
    parameter integer REMOVE_REDUNDANCY_OFFSET = 1 from [0:1];

    // Calibration phase encoding.
    // phase=0: zero-search sign measurement.
    // phase=1: non-binary SAR search using 16,10,6,4,2,1.
    integer phase;
    integer target_idx;
    integer target_side;       // 0: BITD/P target, 1: BITU/N target.
    integer search_step;
    integer search_mask;
    integer trial_mask;
    integer target_mask;
    integer wall_mask;
    integer residual_sign;
    integer q_d;
    integer q_u;
    integer q_mag;
    integer q_scale;
    integer weight_frac_bits;
    integer avg_pairs;
    integer repeat_idx;
    integer accum_q_d;
    integer accum_q_u;
    integer residual_sum;
    integer residual_avg;
    integer first_pair_sum;
    integer diversity_i;

    integer cal_mode_i;
    integer cal_done_i;
    integer cal_error_i;
    integer cal_armed_i;
    integer cal_started_i;
    integer measurement_ready_i;
    integer finish_pending_i;
    integer frame_active_i;
    integer invalid_count;

    integer d_mask;
    integer u_mask;

    // Calibrated differential raw-decision weights in Q(weight_frac_bits)
    // format; legacy FRAC_BITS values below six are promoted.
    // w0..w13 follow BP<0:13>: C12, C11, C10, C9, CR, C8, C7,
    // C6, C5, C4, C3, C2, C1, terminal.
    integer w0, w1, w2, w3, w4, w5, w6;
    integer w7, w8, w9, w10, w11, w12, w13;
    integer candidate_weight;
    integer measured_weight;
    integer wall_weight;
    integer nominal_weight;

    integer cmp_p_gt_n;
    integer target_is_higher;
    integer keep_trial;
    integer cmp_valid;
    integer force_keep_trial;
    integer saturation_i;

    integer clk_sar_i;
    integer clk00_i;
    integer cal_clk_i;

    integer r0, r1, r2, r3, r4, r5, r6;
    integer r7, r8, r9, r10, r11, r12, r13;
    integer raw_sum;
    integer total_weight_q;
    integer redundancy_offset_q;
    integer centered_sum;
    integer adc_code;
    integer b0, b1, b2, b3, b4, b5;
    integer b6, b7, b8, b9, b10, b11;

    real vlogic;
    real vth;
    real cmp_delta;
    real cmp_valid_min;
    real scaled_code;

    genvar g;

    analog begin
        vlogic = V(DVDD, DGND);
        vth = VTH_FRACTION * vlogic;
        cmp_valid_min = CMP_VALID_FRACTION * vlogic;

        @(initial_step) begin
            weight_frac_bits = (FRAC_BITS < 6) ? 6 : FRAC_BITS;
            q_scale = 1 << weight_frac_bits;
            avg_pairs = 1 << AVG_PAIRS_LOG2;
            phase = 0;
            target_idx = 5;             // stage 5: C8.
            target_mask = 32;
            wall_mask = 8128;           // C1..C7 -> bits 6..12.
            target_side = 0;
            search_step = 0;
            search_mask = 0;
            trial_mask = 0;
            residual_sign = 0;
            q_d = 0;
            q_u = 0;
            q_mag = 0;
            repeat_idx = 0;
            accum_q_d = 0;
            accum_q_u = 0;
            residual_sum = 0;
            residual_avg = 0;
            first_pair_sum = 0;
            diversity_i = 0;

            cal_mode_i = 0;
            cal_done_i = 0;
            cal_error_i = 0;
            cal_armed_i = 0;
            cal_started_i = 0;
            measurement_ready_i = 0;
            finish_pending_i = 0;
            frame_active_i = 0;
            invalid_count = 0;
            saturation_i = 0;

            d_mask = 0;
            u_mask = 0;

            w0 = 130880;
            w1 = 65408;
            w2 = 32704;
            w3 = 16384;
            w4 = 16384;
            w5 = 8192;
            w6 = 3072;
            w7 = 2048;
            w8 = 1280;
            w9 = 768;
            w10 = 512;
            w11 = 256;
            w12 = 128;
            w13 = 64;

            candidate_weight = 0;
            wall_weight = 0;
            nominal_weight = 0;

            clk_sar_i = (V(CLK_SAR, DGND) > vth) ? 1 : 0;
            clk00_i = (V(CLK00, DGND) > vth) ? 1 : 0;
            cal_clk_i = (V(CAL_CLK, DGND) > vth) ? 1 : 0;

            adc_code = 0;

            // A bypassed instance immediately produces nominal decoded output.
            // Otherwise, a low CAL_RST at t=0 arms the foreground sequence.
            if (CAL_BYPASS != 0) begin
                cal_mode_i = 0;
                cal_done_i = 1;
                cal_armed_i = 0;
            end else if (V(CAL_RST, DGND) < vth) begin
                cal_mode_i = 1;
                cal_armed_i = 1;
            end
        end

        // Recalibration reset.  A new falling edge starts a new foreground run.
        @(cross(V(CAL_RST, DGND) - vth, +1)) begin
            weight_frac_bits = (FRAC_BITS < 6) ? 6 : FRAC_BITS;
            q_scale = 1 << weight_frac_bits;
            avg_pairs = 1 << AVG_PAIRS_LOG2;
            phase = 0;
            target_idx = 5;
            target_mask = 32;
            wall_mask = 8128;
            target_side = 0;
            search_step = 0;
            search_mask = 0;
            trial_mask = 0;
            residual_sign = 0;
            q_d = 0;
            q_u = 0;
            q_mag = 0;
            repeat_idx = 0;
            accum_q_d = 0;
            accum_q_u = 0;
            residual_sum = 0;
            residual_avg = 0;
            first_pair_sum = 0;
            diversity_i = 0;

            cal_mode_i = 0;
            cal_done_i = (CAL_BYPASS != 0) ? 1 : 0;
            cal_error_i = 0;
            cal_armed_i = 0;
            cal_started_i = 0;
            measurement_ready_i = 0;
            finish_pending_i = 0;
            frame_active_i = 0;
            invalid_count = 0;
            saturation_i = 0;

            d_mask = 0;
            u_mask = 0;

            w0 = 130880;
            w1 = 65408;
            w2 = 32704;
            w3 = 16384;
            w4 = 16384;
            w5 = 8192;
            w6 = 3072;
            w7 = 2048;
            w8 = 1280;
            w9 = 768;
            w10 = 512;
            w11 = 256;
            w12 = 128;
            w13 = 64;

            adc_code = 0;
        end

        @(cross(V(CAL_RST, DGND) - vth, -1)) begin
            if (CAL_BYPASS == 0) begin
            phase = 0;
            target_idx = 5;
            target_mask = 32;
            wall_mask = 8128;
            target_side = 0;
            search_step = 0;
            search_mask = 0;
            trial_mask = 0;
            residual_sign = 0;
            q_d = 0;
            q_u = 0;
            q_mag = 0;
            repeat_idx = 0;
            accum_q_d = 0;
            accum_q_u = 0;
            residual_sum = 0;
            residual_avg = 0;
            first_pair_sum = 0;
            diversity_i = 0;

            cal_mode_i = 1;
            cal_done_i = 0;
            cal_error_i = 0;
            cal_armed_i = 1;
            cal_started_i = 0;
            measurement_ready_i = 0;
            finish_pending_i = 0;
            frame_active_i = 0;
            invalid_count = 0;
            saturation_i = 0;

            d_mask = 0;
            u_mask = 0;

            if (DEBUG != 0)
                $strobe("DEC_CAL_PHY start t=%g", $abstime);
            end
        end

        // RST1 rising marks the beginning of the comparator RST/IAZ interval.
        // Invalidate the frame immediately so stale latch outputs cannot be
        // consumed.  It is also the atomic CAL-to-normal handoff point.
        @(cross(V(RST1, DGND) - vth, +1)) begin
            frame_active_i = 0;
            cal_started_i = 0;
            measurement_ready_i = 0;
            d_mask = 0;
            u_mask = 0;
            if ((cal_mode_i != 0) && (finish_pending_i != 0)) begin
                    cal_mode_i = 0;
                    cal_armed_i = 0;
                    cal_started_i = 0;
                    measurement_ready_i = 0;
                    d_mask = 0;
                    u_mask = 0;

                    // A failed calibration never leaves a partially calibrated
                    // decoder active.  Fall back atomically to nominal Q weights;
                    // DONE means the foreground interval has ended, while ERR
                    // tells the testbench that the nominal fallback is in use.
                    if (cal_error_i != 0) begin
                        w0 = 130880;
                        w1 = 65408;
                        w2 = 32704;
                        w3 = 16384;
                        w4 = 16384;
                        w5 = 8192;
                        w6 = 3072;
                        w7 = 2048;
                        w8 = 1280;
                        w9 = 768;
                        w10 = 512;
                        w11 = 256;
                        w12 = 128;
                        w13 = 64;
                    end
                    cal_done_i = 1;

                    if (DEBUG != 0) begin
                        $strobe("DEC_CAL_PHY finish t=%g done=%0d err=%0d",
                            $abstime, cal_done_i, cal_error_i);
                        $strobe("DEC_CAL_PHY weights_q={%0d,%0d,%0d,%0d,%0d,%0d,%0d,%0d,%0d,%0d,%0d,%0d,%0d,%0d} Q=%0d pairs=%0d",
                            w0, w1, w2, w3, w4, w5, w6, w7, w8,
                            w9, w10, w11, w12, w13, weight_frac_bits, avg_pairs);
                    end
            end
        end

        // RST1 falls about 4 ns before COM_IAZ leaves reset.  The first
        // following CAL_CLK falling edge establishes the CDAC precharge state;
        // the first actual comparator evaluation therefore starts at the next
        // CAL_CLK rising edge, after comparator reset has ended.
        @(cross(V(RST1, DGND) - vth, -1)) begin
            if ((cal_mode_i != 0) && (finish_pending_i == 0)) begin
                frame_active_i = 1;
                cal_started_i = 0;
                measurement_ready_i = 0;
                d_mask = 0;
                u_mask = 0;
                if (DEBUG != 0)
                    $strobe("DEC_CAL_PHY frame start target=%0d side=%0d pair=%0d t=%g",
                        target_idx, target_side, repeat_idx, $abstime);
            end
        end

        // CAL_CLK rising releases the top-plate VCM switch.  The output
        // transition is delayed by TD_CAL, and the real comparator is fired
        // later by TD_CMP_CAL.
        @(cross(V(CAL_CLK, DGND) - vth, +1)) begin
            if ((cal_mode_i != 0) && (frame_active_i != 0) &&
                (cal_started_i != 0) &&
                (finish_pending_i == 0)) begin
                if (target_side == 0) begin
                    d_mask = target_mask;
                    if (phase == 0)
                        u_mask = 0;
                    else if (residual_sign > 0)
                        u_mask = trial_mask;
                    else
                        u_mask = 0;
                end else begin
                    u_mask = target_mask;
                    if (phase == 0)
                        d_mask = 0;
                    else if (residual_sign > 0)
                        d_mask = trial_mask;
                    else
                        d_mask = 0;
                end
                measurement_ready_i = 1;
            end
        end

        // CAL_CLK falling captures the still-valid real comparator outputs and
        // advances exactly one calibration decision.
        @(cross(V(CAL_CLK, DGND) - vth, -1)) begin
            // The first falling edge after CAL_RST only establishes a safe
            // precharge state.  No stale comparator output is consumed.
            if ((cal_mode_i != 0) && (frame_active_i != 0) &&
                (cal_started_i == 0) &&
                (finish_pending_i == 0)) begin
                cal_started_i = 1;
                measurement_ready_i = 0;
                if (target_side == 0) begin
                    d_mask = wall_mask;
                    if ((phase == 1) && (residual_sign < 0))
                        u_mask = trial_mask;
                    else
                        u_mask = 0;
                end else begin
                    u_mask = wall_mask;
                    if ((phase == 1) && (residual_sign < 0))
                        d_mask = trial_mask;
                    else
                        d_mask = 0;
                end
            end else if ((cal_mode_i != 0) && (frame_active_i != 0) &&
                (cal_started_i != 0) &&
                (measurement_ready_i != 0) && (finish_pending_i == 0)) begin

                cmp_delta = V(COMP, DGND) - V(COMN, DGND);
                if (cmp_delta < 0.0)
                    cmp_valid = ((-cmp_delta) > cmp_valid_min) ? 1 : 0;
                else
                    cmp_valid = (cmp_delta > cmp_valid_min) ? 1 : 0;
                force_keep_trial = 0;

                if (cmp_valid == 0) begin
                    invalid_count = invalid_count + 1;
                    if (invalid_count > MAX_INVALID) begin
                        if ((ZERO_ON_INVALID_PHASE0 != 0) &&
                            (phase == 0)) begin
                            // Near equality is expected for C10/C11/C12
                            // against the redundant exact walls.  Force the
                            // residual search to start from the positive side;
                            // if the true residue is zero, every trial is
                            // rejected and q=0 is accumulated.
                            invalid_count = 0;
                            residual_sign = 1;
                            phase = 1;
                            search_step = 0;
                            search_mask = 0;
                            trial_mask = 64;
                            if (DEBUG != 0)
                                $strobe("DEC_CAL_PHY zero-residue target=%0d side=%0d t=%g",
                                    target_idx, target_side, $abstime);
                        end else if ((ZERO_ON_INVALID_PHASE1 != 0) &&
                            (phase == 1)) begin
                            // A binary-search trial can hit the residue
                            // exactly.  Keep that trial and let the remaining
                            // smaller trials reject normally.
                            invalid_count = 0;
                            cmp_valid = 1;
                            force_keep_trial = 1;
                            if (DEBUG != 0)
                                $strobe("DEC_CAL_PHY exact-search-hit target=%0d side=%0d trial=%0d t=%g",
                                    target_idx, target_side, trial_mask,
                                    $abstime);
                        end else begin
                            cal_error_i = 1;
                            finish_pending_i = 1;
                            if (DEBUG != 0)
                                $strobe("DEC_CAL_PHY invalid comparator target=%0d side=%0d t=%g",
                                    target_idx, target_side, $abstime);
                        end
                    end
                end

                if (cmp_valid != 0) begin
                    invalid_count = 0;

                    // Raw convention: COMP falling below COMN means P is
                    // higher than N.  CMP_SWAP=1 flips this raw convention;
                    // this is required by the current COM_IAZ instance/CDF.
                    if (force_keep_trial == 0) begin
                        cmp_p_gt_n = (V(COMP, DGND) < V(COMN, DGND)) ? 1 : 0;
                        if (CMP_SWAP != 0)
                            cmp_p_gt_n = 1 - cmp_p_gt_n;

                        // Normalize the comparator result to "target-side top
                        // plate is higher than search-side top plate".
                        if (target_side == 0)
                            target_is_higher = cmp_p_gt_n;
                        else
                            target_is_higher = 1 - cmp_p_gt_n;
                    end

                    if (phase == 0) begin
                        // With the actual SWITCH_CAL precharge/residue mapping,
                        // target-side top plate higher means target weight is
                        // larger than the calibrated wall.
                        residual_sign = (target_is_higher != 0) ? 1 : -1;
                        phase = 1;
                        search_step = 0;
                        search_mask = 0;
                        trial_mask = 64;   // First trial: stage 6, C7.
                    end else begin
                        // Keep a trial only while the compensated residue has
                        // not crossed zero under the actual switch polarity.
                        if (force_keep_trial != 0)
                            keep_trial = 1;
                        else if (residual_sign > 0)
                            keep_trial = target_is_higher;
                        else
                            keep_trial = 1 - target_is_higher;

                        if (keep_trial != 0)
                            search_mask = trial_mask;

                        if (search_step < 6) begin
                            search_step = search_step + 1;
                            case (search_step)
                                1: trial_mask = search_mask | 128;   // C6.
                                2: trial_mask = search_mask | 256;   // C5.
                                3: trial_mask = search_mask | 512;   // C4.
                                4: trial_mask = search_mask | 1024;  // C3.
                                5: trial_mask = search_mask | 2048;  // C2.
                                default: trial_mask = search_mask | 4096; // C1.
                            endcase
                        end else begin
                            // Do not force the final 1C decision.  Keeping the
                            // actual comparator decision allows repeated noisy
                            // trials to encode a fractional-LSB mean in Q format.
                            q_mag = 0;
                            if ((search_mask & 64)   != 0) q_mag = q_mag + (w6 + 1)/2;
                            if ((search_mask & 4096) != 0) q_mag = q_mag + (w12 + 1)/2;
                            if ((search_mask & 2048) != 0) q_mag = q_mag + (w11 + 1)/2;
                            if ((search_mask & 1024) != 0) q_mag = q_mag + (w10 + 1)/2;
                            if ((search_mask & 512)  != 0) q_mag = q_mag + (w9 + 1)/2;
                            if ((search_mask & 256)  != 0) q_mag = q_mag + (w8 + 1)/2;
                            if ((search_mask & 128)  != 0) q_mag = q_mag + (w7 + 1)/2;

                            saturation_i = ((search_mask == 8128) &&
                                (force_keep_trial == 0) &&
                                (keep_trial != 0)) ? 1 : 0;

                            // One complete sign-plus-seven-bit search consumes
                            // one valid converter frame.  Block all remaining
                            // CAL_CLK edges until the next RST1 falling edge.
                            frame_active_i = 0;
                            cal_started_i = 0;
                            measurement_ready_i = 0;

                            if (target_side == 0) begin
                                // Bottom-plate motion makes the observed
                                // q_mag is the lower edge of a two-decoder-LSB
                                // quantization bin.  D+ is the signed bin-center
                                // SAR output used by Huang (4.17).
                                q_d = residual_sign * (2*q_mag + q_scale);
                                if (DEBUG != 0)
                                    $strobe("DEC_CAL_PHY measure target=%0d pair=%0d side=D q=%0d",
                                        target_idx, repeat_idx, q_d);

                                if (saturation_i != 0) begin
                                    cal_error_i = 1;
                                    finish_pending_i = 1;
                                end else begin
                                    // Mirror measurement: BITU/N becomes target.
                                    target_side = 1;
                                    phase = 0;
                                    search_step = 0;
                                    search_mask = 0;
                                    trial_mask = 0;
                                    residual_sign = 0;
                                end
                            end else begin
                                // Polarity-normalized -D- at the same bin-center
                                // convention as D+.
                                q_u = residual_sign * (2*q_mag + q_scale);
                                if (DEBUG != 0)
                                    $strobe("DEC_CAL_PHY measure target=%0d pair=%0d side=U qD=%0d qU=%0d",
                                        target_idx, repeat_idx, q_d, q_u);

                                if (repeat_idx == 0)
                                    first_pair_sum = q_d + q_u;
                                else if ((q_d + q_u) != first_pair_sum)
                                    diversity_i = 1;

                                if (saturation_i != 0) begin
                                    cal_error_i = 1;
                                    finish_pending_i = 1;
                                end else if (repeat_idx < (avg_pairs - 1)) begin
                                    // One Huang positive/negative pair is done.
                                    // Accumulate signed residual codes, then run
                                    // the same physical experiment again.
                                    accum_q_d = accum_q_d + q_d;
                                    accum_q_u = accum_q_u + q_u;
                                    repeat_idx = repeat_idx + 1;
                                    target_side = 0;
                                    phase = 0;
                                    search_step = 0;
                                    search_mask = 0;
                                    trial_mask = 0;
                                    residual_sign = 0;
                                    q_d = 0;
                                    q_u = 0;
                                end else begin
                                    accum_q_d = accum_q_d + q_d;
                                    accum_q_u = accum_q_u + q_u;

                                    // Recursive calibrated wall in differential
                                    // raw-decision Q units.  The residual is
                                    // averaged separately from the Q format.
                                    case (target_idx)
                                        6: begin
                                            wall_weight = w7 + w9 + w11;
                                            nominal_weight = 48*q_scale;
                                        end
                                        5: begin
                                            wall_weight = w6 + w7 + w8 + w9 +
                                                w10 + w11 + w12;
                                            nominal_weight = 128*q_scale;
                                        end
                                        3: begin
                                            wall_weight = w5 + w6 + w7 + w8 +
                                                w9 + w10 + w11 + w12;
                                            nominal_weight = 256*q_scale;
                                        end
                                        4: begin
                                            // CR is a second direct 2C branch.
                                            // Measure it against the same
                                            // C1..C8 wall as C9.
                                            wall_weight = w5 + w6 + w7 + w8 +
                                                w9 + w10 + w11 + w12;
                                            nominal_weight = 256*q_scale;
                                        end
                                        2: begin
                                            // Exact redundant wall: C9 + CR.
                                            wall_weight = w3 + w4;
                                            nominal_weight = 512*q_scale;
                                        end
                                        1: begin
                                            // Exact redundant wall: C10+C9+CR.
                                            wall_weight = w2 + w3 + w4;
                                            nominal_weight = 1024*q_scale;
                                        end
                                        default: begin
                                            // Exact redundant wall:
                                            // C11+C10+C9+CR.
                                            wall_weight = w1 + w2 + w3 + w4;
                                            nominal_weight = 2048*q_scale;
                                        end
                                    endcase

                                    residual_sum = accum_q_d + accum_q_u;
                                    // qD is D+ in the positive CDAC direction.
                                    // qU has already been polarity-normalized,
                                    // so qU=-D-.  Therefore this implements
                                    // Huang (4.19): (D+ - D-)/2, followed by
                                    // the configured pair average.
                                    if (residual_sum >= 0)
                                        residual_avg = (residual_sum + avg_pairs) / (2*avg_pairs);
                                    else
                                        residual_avg = (residual_sum - avg_pairs) / (2*avg_pairs);

                                    // qD/qU were converted from the physical
                                    // half-weight search domain to centered
                                    // decoder-weight units at measurement time.
                                    candidate_weight = wall_weight + residual_avg;
                                    measured_weight = candidate_weight;

                                    if ((candidate_weight <
                                            nominal_weight * (1.0 - WEIGHT_TOL)) ||
                                        (candidate_weight >
                                            nominal_weight * (1.0 + WEIGHT_TOL))) begin
                                        cal_error_i = 1;
                                        finish_pending_i = 1;
                                        if (DEBUG != 0)
                                            $strobe("DEC_CAL_PHY weight error target=%0d wall=%0d residual_sum=%0d residual_avg=%0d candidate=%0d nominal=%0d",
                                                target_idx, wall_weight,
                                                residual_sum, residual_avg,
                                                candidate_weight,
                                                nominal_weight);
                                    end else begin
                                        case (target_idx)
                                            0: w0 = candidate_weight;
                                            1: w1 = candidate_weight;
                                            2: w2 = candidate_weight;
                                            3: w3 = candidate_weight;
                                            4: w4 = candidate_weight;
                                            5: w5 = candidate_weight;
                                            6: w6 = candidate_weight;
                                        endcase

                                        if (DEBUG != 0)
                                            $strobe("DEC_CAL_PHY weight target=%0d wall=%0d measured_q=%0d value_q=%0d value=%g pairs=%0d residual_sum=%0d residual_avg=%0d diversity=%0d snap=%0d",
                                                target_idx, wall_weight,
                                                measured_weight,
                                                candidate_weight,
                                                1.0*candidate_weight/q_scale,
                                                avg_pairs, residual_sum,
                                                residual_avg, diversity_i,
                                                (candidate_weight != measured_weight));

                                        if (target_idx == 0) begin
                                            finish_pending_i = 1;
                                        end else begin
                                            // Physical calibration sequence:
                                            // C8 -> C9 -> CR -> C10 -> C11 -> C12.
                                            if (target_idx == 5) begin
                                                target_idx = 3;
                                                target_mask = 8;
                                                wall_mask = 8160;  // C1..C8.
                                            end else if (target_idx == 3) begin
                                                target_idx = 4;
                                                target_mask = 16;
                                                wall_mask = 8160;  // C1..C8.
                                            end else if (target_idx == 4) begin
                                                target_idx = 2;
                                                target_mask = 4;
                                                wall_mask = 24;    // C9 + CR.
                                            end else if (target_idx == 2) begin
                                                target_idx = 1;
                                                target_mask = 2;
                                                wall_mask = 28;    // C10+C9+CR.
                                            end else if (target_idx == 1) begin
                                                target_idx = 0;
                                                target_mask = 1;
                                                wall_mask = 30;    // C11+C10+C9+CR.
                                            end else begin
                                                cal_error_i = 1;
                                                finish_pending_i = 1;
                                            end
                                            target_side = 0;
                                            phase = 0;
                                            search_step = 0;
                                            search_mask = 0;
                                            trial_mask = 0;
                                            residual_sign = 0;
                                            q_d = 0;
                                            q_u = 0;
                                            repeat_idx = 0;
                                            accum_q_d = 0;
                                            accum_q_u = 0;
                                            residual_sum = 0;
                                            residual_avg = 0;
                                            first_pair_sum = 0;
                                            diversity_i = 0;
                                        end
                                    end
                                end
                            end
                        end
                    end
                end

                measurement_ready_i = 0;
                // While CAL_CLK is low, SWITCH_CAL clamps the top plates to
                // VCM.  Prepare the reference state for the next independent
                // physical comparison before the next rising edge.
                if ((finish_pending_i != 0) || (frame_active_i == 0)) begin
                    d_mask = 0;
                    u_mask = 0;
                end else if (target_side == 0) begin
                    d_mask = wall_mask;
                    if ((phase == 1) && (residual_sign < 0))
                        u_mask = trial_mask;
                    else
                        u_mask = 0;
                end else begin
                    u_mask = wall_mask;
                    if ((phase == 1) && (residual_sign < 0))
                        d_mask = trial_mask;
                    else
                        d_mask = 0;
                end
            end
        end

        // SOUT is no longer part of calibration timing.  It only latches and
        // decodes a completed normal SAR conversion.  The existing test_0716
        // wiring has BP<13>=BITP<13> (MSB) through BP<0>=BITP<0> (terminal),
        // while w0..w13 are stored in conversion-stage order.  Reverse the BP
        // bus here so no PN-buffer rewiring is required.
        @(cross(V(SOUT, DGND) - vth, +1)) begin
            if ((cal_done_i != 0) && (cal_mode_i == 0)) begin

                r0  = (V(BP[13], DGND) > vth) ? 1 : 0;
                r1  = (V(BP[12], DGND) > vth) ? 1 : 0;
                r2  = (V(BP[11], DGND) > vth) ? 1 : 0;
                r3  = (V(BP[10], DGND) > vth) ? 1 : 0;
                r4  = (V(BP[9],  DGND) > vth) ? 1 : 0;
                r5  = (V(BP[8],  DGND) > vth) ? 1 : 0;
                r6  = (V(BP[7],  DGND) > vth) ? 1 : 0;
                r7  = (V(BP[6],  DGND) > vth) ? 1 : 0;
                r8  = (V(BP[5],  DGND) > vth) ? 1 : 0;
                r9  = (V(BP[4],  DGND) > vth) ? 1 : 0;
                r10 = (V(BP[3],  DGND) > vth) ? 1 : 0;
                r11 = (V(BP[2],  DGND) > vth) ? 1 : 0;
                r12 = (V(BP[1],  DGND) > vth) ? 1 : 0;
                r13 = (V(BP[0],  DGND) > vth) ? 1 : 0;

                if (RAW_INVERT != 0) begin
                    r1 = 1-r1;   r2 = 1-r2;   r3 = 1-r3;
                    r4 = 1-r4;   r5 = 1-r5;   r6 = 1-r6;
                    r7 = 1-r7;   r8 = 1-r8;   r9 = 1-r9;
                    r10 = 1-r10; r11 = 1-r11; r12 = 1-r12;
                    r13 = 1-r13;
                end
                if (FIRST_INVERT != 0)
                    r0 = 1-r0;

                raw_sum = r0*w0 + r1*w1 + r2*w2 + r3*w3 + r4*w4 +
                    r5*w5 + r6*w6 + r7*w7 + r8*w8 + r9*w9 +
                    r10*w10 + r11*w11 + r12*w12 + r13*w13;

                total_weight_q = w0 + w1 + w2 + w3 + w4 + w5 + w6 + w7 +
                    w8 + w9 + w10 + w11 + w12 + w13;

                if ((NORMALIZE_REDUNDANT_RANGE != 0) &&
                    (total_weight_q > 0)) begin
                    // Calibration remains in the physical/raw Q domain.  Only
                    // the final output formatter applies this linear gain so
                    // raw=0 maps to code 0, raw=sum(w) maps to 4095, and the
                    // complementary midscale pair remains centered at 2047.5.
                    scaled_code = 4095.0 * raw_sum / total_weight_q;
                end else begin
                    // Backward-compatible offset-only formatter.
                    if (REMOVE_REDUNDANCY_OFFSET != 0) begin
                        redundancy_offset_q = total_weight_q - 4095*q_scale;
                        if (redundancy_offset_q >= 0)
                            centered_sum = raw_sum -
                                (redundancy_offset_q + 1)/2;
                        else
                            centered_sum = raw_sum -
                                (redundancy_offset_q - 1)/2;
                    end else begin
                        centered_sum = raw_sum;
                    end
                    scaled_code = 1.0 * centered_sum / q_scale;
                end
                adc_code = $rtoi(scaled_code + 0.5);
                if (adc_code < 0)
                    adc_code = 0;
                else if (adc_code > 4095)
                    adc_code = 4095;
            end
        end

        // Track the normal and calibration clocks discretely.  CAL_CLK is a
        // new external calibration clock; CLK remains the single physical
        // comparator-clock output.
        @(cross(V(CLK_SAR, DGND) - vth, +1)) clk_sar_i = 1;
        @(cross(V(CLK_SAR, DGND) - vth, -1)) clk_sar_i = 0;
        @(cross(V(CLK00, DGND) - vth, +1)) clk00_i = 1;
        @(cross(V(CLK00, DGND) - vth, -1)) clk00_i = 0;
        @(cross(V(CAL_CLK, DGND) - vth, +1)) cal_clk_i = 1;
        @(cross(V(CAL_CLK, DGND) - vth, -1)) cal_clk_i = 0;

        b0  = (adc_code      ) & 1;
        b1  = (adc_code >>  1) & 1;
        b2  = (adc_code >>  2) & 1;
        b3  = (adc_code >>  3) & 1;
        b4  = (adc_code >>  4) & 1;
        b5  = (adc_code >>  5) & 1;
        b6  = (adc_code >>  6) & 1;
        b7  = (adc_code >>  7) & 1;
        b8  = (adc_code >>  8) & 1;
        b9  = (adc_code >>  9) & 1;
        b10 = (adc_code >> 10) & 1;
        b11 = (adc_code >> 11) & 1;

        V(CAL,  DGND) <+ vlogic * transition(cal_mode_i,  TD, TR, TF);
        V(DONE, DGND) <+ vlogic * transition(cal_done_i,  TD, TR, TF);
        V(ERR,  DGND) <+ vlogic * transition(cal_error_i, TD, TR, TF);
        V(CLK, DGND) <+ vlogic * (
            (1 - cal_mode_i) * transition(clk_sar_i, TD, TR, TF) +
            cal_mode_i * transition(
                cal_clk_i * frame_active_i * cal_started_i *
                    (1 - finish_pending_i),
                TD_CMP_CAL, TR, TF));

        V(Bit[0],  DGND) <+ vlogic * transition(b0,  TD, TR, TF);
        V(Bit[1],  DGND) <+ vlogic * transition(b1,  TD, TR, TF);
        V(Bit[2],  DGND) <+ vlogic * transition(b2,  TD, TR, TF);
        V(Bit[3],  DGND) <+ vlogic * transition(b3,  TD, TR, TF);
        V(Bit[4],  DGND) <+ vlogic * transition(b4,  TD, TR, TF);
        V(Bit[5],  DGND) <+ vlogic * transition(b5,  TD, TR, TF);
        V(Bit[6],  DGND) <+ vlogic * transition(b6,  TD, TR, TF);
        V(Bit[7],  DGND) <+ vlogic * transition(b7,  TD, TR, TF);
        V(Bit[8],  DGND) <+ vlogic * transition(b8,  TD, TR, TF);
        V(Bit[9],  DGND) <+ vlogic * transition(b9,  TD, TR, TF);
        V(Bit[10], DGND) <+ vlogic * transition(b10, TD, TR, TF);
        V(Bit[11], DGND) <+ vlogic * transition(b11, TD, TR, TF);

        for (g = 0; g < 13; g = g + 1) begin
            V(BITD_CAL[g], DGND) <+ vlogic * transition(
                (d_mask >> g) & 1, TD_CAL, TR, TF);
            V(BITU_CAL[g], DGND) <+ vlogic * transition(
                (u_mask >> g) & 1, TD_CAL, TR, TF);
        end
    end
endmodule
