openResults("/home/meow/jxy/codex_sandbox/sar0716_calibration_20260717/mismatch_case02_sigma03x_full_frozen_avg16_fftraw/psf")
selectResult('tran)
ocnPrint(v("OUT") ?numberNotation (quote scientific) ?from 1.298505u ?to 13.998505u ?step 100n ?numSpaces 1 ?output "/home/meow/jxy/codex_sandbox/sar0716_calibration_20260717/mismatch_case02_sigma03x_full_frozen_avg16_fftraw/exports/OUT.txt")
ocnPrint(v("BP<0>") ?numberNotation (quote scientific) ?from 1.298505u ?to 13.998505u ?step 100n ?numSpaces 1 ?output "/home/meow/jxy/codex_sandbox/sar0716_calibration_20260717/mismatch_case02_sigma03x_full_frozen_avg16_fftraw/exports/BP_0_.txt")
ocnPrint(v("BP<1>") ?numberNotation (quote scientific) ?from 1.298505u ?to 13.998505u ?step 100n ?numSpaces 1 ?output "/home/meow/jxy/codex_sandbox/sar0716_calibration_20260717/mismatch_case02_sigma03x_full_frozen_avg16_fftraw/exports/BP_1_.txt")
ocnPrint(v("BP<2>") ?numberNotation (quote scientific) ?from 1.298505u ?to 13.998505u ?step 100n ?numSpaces 1 ?output "/home/meow/jxy/codex_sandbox/sar0716_calibration_20260717/mismatch_case02_sigma03x_full_frozen_avg16_fftraw/exports/BP_2_.txt")
ocnPrint(v("BP<3>") ?numberNotation (quote scientific) ?from 1.298505u ?to 13.998505u ?step 100n ?numSpaces 1 ?output "/home/meow/jxy/codex_sandbox/sar0716_calibration_20260717/mismatch_case02_sigma03x_full_frozen_avg16_fftraw/exports/BP_3_.txt")
ocnPrint(v("BP<4>") ?numberNotation (quote scientific) ?from 1.298505u ?to 13.998505u ?step 100n ?numSpaces 1 ?output "/home/meow/jxy/codex_sandbox/sar0716_calibration_20260717/mismatch_case02_sigma03x_full_frozen_avg16_fftraw/exports/BP_4_.txt")
ocnPrint(v("BP<5>") ?numberNotation (quote scientific) ?from 1.298505u ?to 13.998505u ?step 100n ?numSpaces 1 ?output "/home/meow/jxy/codex_sandbox/sar0716_calibration_20260717/mismatch_case02_sigma03x_full_frozen_avg16_fftraw/exports/BP_5_.txt")
ocnPrint(v("BP<6>") ?numberNotation (quote scientific) ?from 1.298505u ?to 13.998505u ?step 100n ?numSpaces 1 ?output "/home/meow/jxy/codex_sandbox/sar0716_calibration_20260717/mismatch_case02_sigma03x_full_frozen_avg16_fftraw/exports/BP_6_.txt")
ocnPrint(v("BP<7>") ?numberNotation (quote scientific) ?from 1.298505u ?to 13.998505u ?step 100n ?numSpaces 1 ?output "/home/meow/jxy/codex_sandbox/sar0716_calibration_20260717/mismatch_case02_sigma03x_full_frozen_avg16_fftraw/exports/BP_7_.txt")
ocnPrint(v("BP<8>") ?numberNotation (quote scientific) ?from 1.298505u ?to 13.998505u ?step 100n ?numSpaces 1 ?output "/home/meow/jxy/codex_sandbox/sar0716_calibration_20260717/mismatch_case02_sigma03x_full_frozen_avg16_fftraw/exports/BP_8_.txt")
ocnPrint(v("BP<9>") ?numberNotation (quote scientific) ?from 1.298505u ?to 13.998505u ?step 100n ?numSpaces 1 ?output "/home/meow/jxy/codex_sandbox/sar0716_calibration_20260717/mismatch_case02_sigma03x_full_frozen_avg16_fftraw/exports/BP_9_.txt")
ocnPrint(v("BP<10>") ?numberNotation (quote scientific) ?from 1.298505u ?to 13.998505u ?step 100n ?numSpaces 1 ?output "/home/meow/jxy/codex_sandbox/sar0716_calibration_20260717/mismatch_case02_sigma03x_full_frozen_avg16_fftraw/exports/BP_10_.txt")
ocnPrint(v("BP<11>") ?numberNotation (quote scientific) ?from 1.298505u ?to 13.998505u ?step 100n ?numSpaces 1 ?output "/home/meow/jxy/codex_sandbox/sar0716_calibration_20260717/mismatch_case02_sigma03x_full_frozen_avg16_fftraw/exports/BP_11_.txt")
ocnPrint(v("BP<12>") ?numberNotation (quote scientific) ?from 1.298505u ?to 13.998505u ?step 100n ?numSpaces 1 ?output "/home/meow/jxy/codex_sandbox/sar0716_calibration_20260717/mismatch_case02_sigma03x_full_frozen_avg16_fftraw/exports/BP_12_.txt")
ocnPrint(v("BP<13>") ?numberNotation (quote scientific) ?from 1.298505u ?to 13.998505u ?step 100n ?numSpaces 1 ?output "/home/meow/jxy/codex_sandbox/sar0716_calibration_20260717/mismatch_case02_sigma03x_full_frozen_avg16_fftraw/exports/BP_13_.txt")
exit()
