openResults("/home/meow/jxy/codex_sandbox/sar0716_calibration_20260717/full_adc_bypass_890m_norm_cx/psf")
selectResult('tran)
ocnPrint(v("OUT") ?numberNotation (quote scientific) ?from 198.505n ?to 12.898505u ?step 100n ?numSpaces 1 ?output "/home/meow/jxy/codex_sandbox/sar0716_calibration_20260717/full_adc_bypass_890m_norm_cx/exports/OUT.txt")
ocnPrint(v("SOUT") ?numberNotation (quote scientific) ?from 198.505n ?to 12.898505u ?step 100n ?numSpaces 1 ?output "/home/meow/jxy/codex_sandbox/sar0716_calibration_20260717/full_adc_bypass_890m_norm_cx/exports/SOUT.txt")
ocnPrint(v("CAL") ?numberNotation (quote scientific) ?from 198.505n ?to 12.898505u ?step 100n ?numSpaces 1 ?output "/home/meow/jxy/codex_sandbox/sar0716_calibration_20260717/full_adc_bypass_890m_norm_cx/exports/CAL.txt")
ocnPrint(v("DONE") ?numberNotation (quote scientific) ?from 198.505n ?to 12.898505u ?step 100n ?numSpaces 1 ?output "/home/meow/jxy/codex_sandbox/sar0716_calibration_20260717/full_adc_bypass_890m_norm_cx/exports/DONE.txt")
ocnPrint(v("ERR") ?numberNotation (quote scientific) ?from 198.505n ?to 12.898505u ?step 100n ?numSpaces 1 ?output "/home/meow/jxy/codex_sandbox/sar0716_calibration_20260717/full_adc_bypass_890m_norm_cx/exports/ERR.txt")
exit()
