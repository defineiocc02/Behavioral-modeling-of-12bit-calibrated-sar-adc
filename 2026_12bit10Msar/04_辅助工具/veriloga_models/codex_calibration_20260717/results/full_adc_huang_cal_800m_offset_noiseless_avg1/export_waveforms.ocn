openResults("/home/meow/jxy/codex_sandbox/sar0716_calibration_20260717/full_adc_huang_cal_800m_offset_noiseless_avg1/psf")
selectResult('tran)
ocnPrint(v("OUT") ?numberNotation (quote scientific) ?numSpaces 1 ?output "/home/meow/jxy/codex_sandbox/sar0716_calibration_20260717/full_adc_huang_cal_800m_offset_noiseless_avg1/exports/OUT.txt")
ocnPrint(v("SOUT") ?numberNotation (quote scientific) ?numSpaces 1 ?output "/home/meow/jxy/codex_sandbox/sar0716_calibration_20260717/full_adc_huang_cal_800m_offset_noiseless_avg1/exports/SOUT.txt")
exit()
