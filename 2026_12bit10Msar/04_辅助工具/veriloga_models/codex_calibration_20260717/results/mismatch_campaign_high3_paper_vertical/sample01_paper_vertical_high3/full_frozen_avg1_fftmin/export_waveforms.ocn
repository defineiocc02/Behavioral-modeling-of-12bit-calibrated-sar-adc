openResults("/home/meow/jxy/codex_sandbox/sar0716_calibration_20260717/sample01_paper_vertical_high3_full_frozen_fft/psf")
selectResult('tran)
ocnPrint(v("OUT") ?numberNotation (quote scientific) ?from 1.298505u ?to 13.998505u ?step 100n ?numSpaces 1 ?output "/home/meow/jxy/codex_sandbox/sar0716_calibration_20260717/sample01_paper_vertical_high3_full_frozen_fft/exports/OUT.txt")
exit()
