openResults("/home/meow/jxy/codex_sandbox/sar0716_calibration_20260717/sourcecenter_sample03_full_huang_fft256/psf")
selectResult('tran)
ocnPrint(v("OUT") ?numberNotation (quote scientific) ?from 1.298505u ?to 26.798505u ?step 100n ?numSpaces 1 ?output "/home/meow/jxy/codex_sandbox/sar0716_calibration_20260717/sourcecenter_sample03_full_huang_fft256/exports/OUT.txt")
exit()
