openResults("/home/meow/jxy/codex_sandbox/sar0716_calibration_20260717/calibration_cdac_ideal/psf")
selectResult('tran)
ocnPrint(v("P") ?numberNotation (quote scientific) ?numSpaces 1 ?output "/home/meow/jxy/codex_sandbox/sar0716_calibration_20260717/calibration_cdac_ideal/exports/P.txt")
ocnPrint(v("N") ?numberNotation (quote scientific) ?numSpaces 1 ?output "/home/meow/jxy/codex_sandbox/sar0716_calibration_20260717/calibration_cdac_ideal/exports/N.txt")
ocnPrint(v("CLK") ?numberNotation (quote scientific) ?numSpaces 1 ?output "/home/meow/jxy/codex_sandbox/sar0716_calibration_20260717/calibration_cdac_ideal/exports/CLK.txt")
ocnPrint(v("CAL") ?numberNotation (quote scientific) ?numSpaces 1 ?output "/home/meow/jxy/codex_sandbox/sar0716_calibration_20260717/calibration_cdac_ideal/exports/CAL.txt")
ocnPrint(v("DONE") ?numberNotation (quote scientific) ?numSpaces 1 ?output "/home/meow/jxy/codex_sandbox/sar0716_calibration_20260717/calibration_cdac_ideal/exports/DONE.txt")
ocnPrint(v("ERR") ?numberNotation (quote scientific) ?numSpaces 1 ?output "/home/meow/jxy/codex_sandbox/sar0716_calibration_20260717/calibration_cdac_ideal/exports/ERR.txt")
exit()
