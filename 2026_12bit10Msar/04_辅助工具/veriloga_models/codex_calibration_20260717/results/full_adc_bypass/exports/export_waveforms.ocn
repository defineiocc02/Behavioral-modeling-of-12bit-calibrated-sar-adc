openResults("/home/meow/jxy/codex_sandbox/sar0716_calibration_20260717/full_adc_bypass/psf")
selectResult('tran)
ocnPrint(v("OUT") ?numberNotation (quote scientific) ?from 12.298505u ?to 24.998505u ?step 100n ?numSpaces 1 ?output "/home/meow/jxy/codex_sandbox/sar0716_calibration_20260717/full_adc_bypass/exports/OUT.txt")
ocnPrint(v("SOUT") ?numberNotation (quote scientific) ?from 12.298505u ?to 24.998505u ?step 100n ?numSpaces 1 ?output "/home/meow/jxy/codex_sandbox/sar0716_calibration_20260717/full_adc_bypass/exports/SOUT.txt")
ocnPrint(v("CAL") ?numberNotation (quote scientific) ?from 12.298505u ?to 24.998505u ?step 100n ?numSpaces 1 ?output "/home/meow/jxy/codex_sandbox/sar0716_calibration_20260717/full_adc_bypass/exports/CAL.txt")
ocnPrint(v("DONE") ?numberNotation (quote scientific) ?from 12.298505u ?to 24.998505u ?step 100n ?numSpaces 1 ?output "/home/meow/jxy/codex_sandbox/sar0716_calibration_20260717/full_adc_bypass/exports/DONE.txt")
ocnPrint(v("ERR") ?numberNotation (quote scientific) ?from 12.298505u ?to 24.998505u ?step 100n ?numSpaces 1 ?output "/home/meow/jxy/codex_sandbox/sar0716_calibration_20260717/full_adc_bypass/exports/ERR.txt")
exit()
