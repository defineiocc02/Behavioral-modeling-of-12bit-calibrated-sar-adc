openResults("/home/meow/jxy/codex_sandbox/sar0716_calibration_20260717/full_adc_bypass_debug2u/psf")
selectResult('tran)
ocnPrint(v("OUT") ?numberNotation (quote scientific) ?from 98.505n ?to 1.998505u ?step 100n ?numSpaces 1 ?output "/home/meow/jxy/codex_sandbox/sar0716_calibration_20260717/full_adc_bypass_debug2u/exports/OUT.txt")
ocnPrint(v("SOUT") ?numberNotation (quote scientific) ?from 98.505n ?to 1.998505u ?step 100n ?numSpaces 1 ?output "/home/meow/jxy/codex_sandbox/sar0716_calibration_20260717/full_adc_bypass_debug2u/exports/SOUT.txt")
ocnPrint(v("BP<0>") ?numberNotation (quote scientific) ?from 98.505n ?to 1.998505u ?step 100n ?numSpaces 1 ?output "/home/meow/jxy/codex_sandbox/sar0716_calibration_20260717/full_adc_bypass_debug2u/exports/BP_0_.txt")
ocnPrint(v("BP<1>") ?numberNotation (quote scientific) ?from 98.505n ?to 1.998505u ?step 100n ?numSpaces 1 ?output "/home/meow/jxy/codex_sandbox/sar0716_calibration_20260717/full_adc_bypass_debug2u/exports/BP_1_.txt")
ocnPrint(v("BP<2>") ?numberNotation (quote scientific) ?from 98.505n ?to 1.998505u ?step 100n ?numSpaces 1 ?output "/home/meow/jxy/codex_sandbox/sar0716_calibration_20260717/full_adc_bypass_debug2u/exports/BP_2_.txt")
ocnPrint(v("BP<3>") ?numberNotation (quote scientific) ?from 98.505n ?to 1.998505u ?step 100n ?numSpaces 1 ?output "/home/meow/jxy/codex_sandbox/sar0716_calibration_20260717/full_adc_bypass_debug2u/exports/BP_3_.txt")
ocnPrint(v("BP<4>") ?numberNotation (quote scientific) ?from 98.505n ?to 1.998505u ?step 100n ?numSpaces 1 ?output "/home/meow/jxy/codex_sandbox/sar0716_calibration_20260717/full_adc_bypass_debug2u/exports/BP_4_.txt")
ocnPrint(v("BP<5>") ?numberNotation (quote scientific) ?from 98.505n ?to 1.998505u ?step 100n ?numSpaces 1 ?output "/home/meow/jxy/codex_sandbox/sar0716_calibration_20260717/full_adc_bypass_debug2u/exports/BP_5_.txt")
ocnPrint(v("BP<6>") ?numberNotation (quote scientific) ?from 98.505n ?to 1.998505u ?step 100n ?numSpaces 1 ?output "/home/meow/jxy/codex_sandbox/sar0716_calibration_20260717/full_adc_bypass_debug2u/exports/BP_6_.txt")
ocnPrint(v("BP<7>") ?numberNotation (quote scientific) ?from 98.505n ?to 1.998505u ?step 100n ?numSpaces 1 ?output "/home/meow/jxy/codex_sandbox/sar0716_calibration_20260717/full_adc_bypass_debug2u/exports/BP_7_.txt")
ocnPrint(v("BP<8>") ?numberNotation (quote scientific) ?from 98.505n ?to 1.998505u ?step 100n ?numSpaces 1 ?output "/home/meow/jxy/codex_sandbox/sar0716_calibration_20260717/full_adc_bypass_debug2u/exports/BP_8_.txt")
ocnPrint(v("BP<9>") ?numberNotation (quote scientific) ?from 98.505n ?to 1.998505u ?step 100n ?numSpaces 1 ?output "/home/meow/jxy/codex_sandbox/sar0716_calibration_20260717/full_adc_bypass_debug2u/exports/BP_9_.txt")
ocnPrint(v("BP<10>") ?numberNotation (quote scientific) ?from 98.505n ?to 1.998505u ?step 100n ?numSpaces 1 ?output "/home/meow/jxy/codex_sandbox/sar0716_calibration_20260717/full_adc_bypass_debug2u/exports/BP_10_.txt")
ocnPrint(v("BP<11>") ?numberNotation (quote scientific) ?from 98.505n ?to 1.998505u ?step 100n ?numSpaces 1 ?output "/home/meow/jxy/codex_sandbox/sar0716_calibration_20260717/full_adc_bypass_debug2u/exports/BP_11_.txt")
ocnPrint(v("BP<12>") ?numberNotation (quote scientific) ?from 98.505n ?to 1.998505u ?step 100n ?numSpaces 1 ?output "/home/meow/jxy/codex_sandbox/sar0716_calibration_20260717/full_adc_bypass_debug2u/exports/BP_12_.txt")
ocnPrint(v("BP<13>") ?numberNotation (quote scientific) ?from 98.505n ?to 1.998505u ?step 100n ?numSpaces 1 ?output "/home/meow/jxy/codex_sandbox/sar0716_calibration_20260717/full_adc_bypass_debug2u/exports/BP_13_.txt")
exit()
