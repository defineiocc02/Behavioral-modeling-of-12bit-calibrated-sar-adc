// Generated mechanically from the frozen Interactive.293 netlist.
// Source: D:\ReedZhao\Document\Obsidian\日常\10_项目区\2026_12bit10Msar\04_辅助工具\veriloga_models\codex_calibration_20260717\source_ro\input_Interactive293.scs
simulator lang=spectre
global 0
parameters temperature=27.0 td=18n IB=300n C=4f N=59 M=128 W1=500n W2=1u \
    WK=2u W3=2u W4=3u W5=4u W6=5u W7=8u W8=12u va=890m Vref=1 vdd=1.8 \
    tdac=2n tdel=5n cbin=1p vcmpre=0.9 F1=8 F4=2 WK1=500n FSR=2 FM7=8 \
    csup=2 tlatch=1.5n FFB=1 VBIASN=800m VBIASP=900m WS=4u L=1 F2=4 WCM=4u \
    F3=F4
include "/home/meow/Desktop/TSMC18RF/tsmc18rf/../models/spectre/rf018.scs" section=tt
include "/home/meow/Desktop/TSMC18RF/tsmc18rf/../models/spectre/rf018.scs" section=tt_3v
include "/home/meow/Desktop/TSMC18RF/tsmc18rf/../models/spectre/rf018.scs" section=tt_na
include "/home/meow/Desktop/TSMC18RF/tsmc18rf/../models/spectre/rf018.scs" section=tt_3vna
include "/home/meow/Desktop/TSMC18RF/tsmc18rf/../models/spectre/rf018.scs" section=tt_m
include "/home/meow/Desktop/TSMC18RF/tsmc18rf/../models/spectre/rf018.scs" section=tt_3m
include "/home/meow/Desktop/TSMC18RF/tsmc18rf/../models/spectre/rf018.scs" section=tt_bip
include "/home/meow/Desktop/TSMC18RF/tsmc18rf/../models/spectre/rf018.scs" section=tt_bip3
include "/home/meow/Desktop/TSMC18RF/tsmc18rf/../models/spectre/rf018.scs" section=dio
include "/home/meow/Desktop/TSMC18RF/tsmc18rf/../models/spectre/rf018.scs" section=dio3
include "/home/meow/Desktop/TSMC18RF/tsmc18rf/../models/spectre/rf018.scs" section=dio_dnw
include "/home/meow/Desktop/TSMC18RF/tsmc18rf/../models/spectre/rf018.scs" section=tt_res
include "/home/meow/Desktop/TSMC18RF/tsmc18rf/../models/spectre/rf018.scs" section=tt_mim
include "/home/meow/Desktop/TSMC18RF/tsmc18rf/../models/spectre/rf018.scs" section=tt_rfmos
include "/home/meow/Desktop/TSMC18RF/tsmc18rf/../models/spectre/rf018.scs" section=tt_rfmos33
include "/home/meow/Desktop/TSMC18RF/tsmc18rf/../models/spectre/rf018.scs" section=tt_rfmim
include "/home/meow/Desktop/TSMC18RF/tsmc18rf/../models/spectre/rf018.scs" section=tt_rfind
include "/home/meow/Desktop/TSMC18RF/tsmc18rf/../models/spectre/rf018.scs" section=tt_rfmvar
include "/home/meow/Desktop/TSMC18RF/tsmc18rf/../models/spectre/rf018.scs" section=tt_rfjvar
include "/home/meow/Desktop/TSMC18RF/tsmc18rf/../models/spectre/rf018.scs" section=tt_rfres_sa
include "/home/meow/Desktop/TSMC18RF/tsmc18rf/../models/spectre/rf018.scs" section=tt_rfres_rpo
include "/home/meow/Desktop/TSMC18RF/tsmc18rf/../models/spectre/rf018.scs" section=tt_rfres_hri
include "/home/meow/Desktop/TSMC18RF/tsmc18rf/../models/spectre/rf018.scs" section=tt_rfesd
include "/home/meow/Desktop/TSMC18RF/tsmc18rf/../models/spectre/rf018.scs" section=tt_bbmvar

subckt NOR1 A AGND AVDD B VOUT
    M4 (net8 B AVDD AVDD) pch l=180.0n w=800n m=1 ad=3.84e-13 as=3.84e-13 \
        pd=2.56u ps=2.56u nrd=0.3375 nrs=0.3375
    M0 (VOUT A net8 AVDD) pch l=180.0n w=800n m=1 ad=3.84e-13 as=3.84e-13 \
        pd=2.56u ps=2.56u nrd=0.3375 nrs=0.3375
    M3 (VOUT A AGND AGND) nch l=180.0n w=250.0n m=1 ad=2.014e-13 \
        as=2.014e-13 pd=1.88u ps=1.88u nrd=1.24 nrs=1.24
    M2 (VOUT B AGND AGND) nch l=180.0n w=250.0n m=1 ad=2.014e-13 \
        as=2.014e-13 pd=1.88u ps=1.88u nrd=1.24 nrs=1.24
ends NOR1

subckt INVX2 IN OUT VDD VSS
    M1 (OUT IN VSS VSS) nch l=180.0n w=500n m=1 ad=2.4e-13 as=2.4e-13 \
        pd=1.96u ps=1.96u nrd=0.54 nrs=0.54
    M0 (OUT IN VDD VDD) pch l=180.0n w=1u m=1 ad=4.8e-13 as=4.8e-13 \
        pd=2.96u ps=2.96u nrd=0.27 nrs=0.27
ends INVX2

subckt INVX3 IN OUT VDD VSS
    M1 (OUT IN VSS VSS) nch l=180.0n w=1u m=1 ad=4.8e-13 as=4.8e-13 \
        pd=2.96u ps=2.96u nrd=0.27 nrs=0.27
    M0 (OUT IN VDD VDD) pch l=180.0n w=2u m=1 ad=9.6e-13 as=9.6e-13 \
        pd=4.96u ps=4.96u nrd=0.135 nrs=0.135
ends INVX3

subckt INVX1 IN OUT VDD VSS
    M0 (OUT IN VDD VDD) pch l=180.0n w=440.0n m=1 ad=2.112e-13 \
        as=2.112e-13 pd=1.84u ps=1.84u nrd=0.613636 nrs=0.613636
    M1 (OUT IN VSS VSS) nch l=180.0n w=220.0n m=1 ad=1.984e-13 \
        as=1.984e-13 pd=1.88u ps=1.88u nrd=1.40909 nrs=1.40909
ends INVX1

subckt COM_IAZ AGND AVDD CLK RST VIN VIP VON VOP
    I287 (CLK AGND AVDD net1 net2) NOR1
    V16 (net42 AGND) vsource dc=vcmpre type=dc
    M136 (V3 VB1 AVDD AVDD) pch_mis l=180.0n*L w=2u multi=(10) ad=5.4e-13 \
        as=6.24e-13 pd=2.54u ps=3.024u nrd=0.135 nrs=0.135
    M135 (VON1 net46 V3 AVDD) pch_mis l=180.0n*L w=1.5u multi=(1*F1*L) \
        ad=(1.5e-06*((4.8e-07+((F1*L-1)*5.4e-07)/2+0)*(int((F1*L+1)/2)-int(F1*L/2))+(F1*L/2)*5.4e-07*(int((F1*L+2)/2)-int((F1*L+1)/2)))+((0*0*((F1*L-1)/2+1-0))*(int((F1*L+1)/2)-int(F1*L/2))+(0*0*int(F1*L/2))*(int((F1*L+2)/2)-int((F1*L+1)/2))))/F1*L \
        as=(1.5e-06*((4.8e-07+((F1*L-1)*5.4e-07)/2+0)*(int((F1*L+1)/2)-int(F1*L/2))+(4.8e-07+4.8e-07+(int(F1*L/2)-1)*5.4e-07+0+0)*(int((F1*L+2)/2)-int((F1*L+1)/2)))+((0*0*((F1*L-1)/2+1-0))*(int((F1*L+1)/2)-int(F1*L/2))+(0*0*(int(F1*L/2)+1-0-0))*(int((F1*L+2)/2)-int((F1*L+1)/2))))/F1*L \
        pd=(((4.8e-07+((F1*L-1)*5.4e-07)/2+0)*(int((F1*L+1)/2)-int(F1*L/2))+(F1*L/2)*5.4e-07*(int((F1*L+2)/2)-int((F1*L+1)/2)))*2+(((F1*L+1)*(int((F1*L+1)/2)-int(F1*L/2))+(F1*L+0)*(int((F1*L+2)/2)-int((F1*L+1)/2)))-((0*(((F1*L+1)*(int((F1*L+1)/2)-int(F1*L/2))+(F1*L+0)*(int((F1*L+2)/2)-int((F1*L+1)/2)))-0))*(int((F1*L+1)/2)-int(F1*L/2))+(0*((F1*L+1)*(int((F1*L+1)/2)-int(F1*L/2))+(F1*L+0)*(int((F1*L+2)/2)-int((F1*L+1)/2))))*(int((F1*L+2)/2)-int((F1*L+1)/2))))*1.5e-06+((0*((F1*L-1)/2+1-0))*(int((F1*L+1)/2)-int(F1*L/2))+(0*int(F1*L/2))*(int((F1*L+2)/2)-int((F1*L+1)/2)))*4)/F1*L \
        ps=(((4.8e-07+((F1*L-1)*5.4e-07)/2+0)*(int((F1*L+1)/2)-int(F1*L/2))+(4.8e-07+4.8e-07+(int(F1*L/2)-1)*5.4e-07+0+0)*(int((F1*L+2)/2)-int((F1*L+1)/2)))*2+(((F1*L+1)*(int((F1*L+1)/2)-int(F1*L/2))+(F1*L+2)*(int((F1*L+2)/2)-int((F1*L+1)/2)))-((0*(((F1*L+1)*(int((F1*L+1)/2)-int(F1*L/2))+(F1*L+2)*(int((F1*L+2)/2)-int((F1*L+1)/2)))-0))*(int((F1*L+1)/2)-int(F1*L/2))+(0*(((F1*L+1)*(int((F1*L+1)/2)-int(F1*L/2))+(F1*L+2)*(int((F1*L+2)/2)-int((F1*L+1)/2)))-0-0))*(int((F1*L+2)/2)-int((F1*L+1)/2))))*1.5e-06+((0*((F1*L-1)/2+1-0))*(int((F1*L+1)/2)-int(F1*L/2))+(0*(int(F1*L/2)+1-0-0))*(int((F1*L+2)/2)-int((F1*L+1)/2)))*4)/F1*L \
        nrd=(5.4e-07+2.7e-07*(F1*2-2))/F1/(1.5e-06*2) \
        nrs=(5.4e-07+2.7e-07*(F1*2-2))/F1/(1.5e-06*2)
    M134 (VOP1 net45 V3 AVDD) pch_mis l=180.0n*L w=1.5u multi=(1*F1*L) \
        ad=(1.5e-06*((4.8e-07+((F1*L-1)*5.4e-07)/2+0)*(int((F1*L+1)/2)-int(F1*L/2))+(F1*L/2)*5.4e-07*(int((F1*L+2)/2)-int((F1*L+1)/2)))+((0*0*((F1*L-1)/2+1-0))*(int((F1*L+1)/2)-int(F1*L/2))+(0*0*int(F1*L/2))*(int((F1*L+2)/2)-int((F1*L+1)/2))))/F1*L \
        as=(1.5e-06*((4.8e-07+((F1*L-1)*5.4e-07)/2+0)*(int((F1*L+1)/2)-int(F1*L/2))+(4.8e-07+4.8e-07+(int(F1*L/2)-1)*5.4e-07+0+0)*(int((F1*L+2)/2)-int((F1*L+1)/2)))+((0*0*((F1*L-1)/2+1-0))*(int((F1*L+1)/2)-int(F1*L/2))+(0*0*(int(F1*L/2)+1-0-0))*(int((F1*L+2)/2)-int((F1*L+1)/2))))/F1*L \
        pd=(((4.8e-07+((F1*L-1)*5.4e-07)/2+0)*(int((F1*L+1)/2)-int(F1*L/2))+(F1*L/2)*5.4e-07*(int((F1*L+2)/2)-int((F1*L+1)/2)))*2+(((F1*L+1)*(int((F1*L+1)/2)-int(F1*L/2))+(F1*L+0)*(int((F1*L+2)/2)-int((F1*L+1)/2)))-((0*(((F1*L+1)*(int((F1*L+1)/2)-int(F1*L/2))+(F1*L+0)*(int((F1*L+2)/2)-int((F1*L+1)/2)))-0))*(int((F1*L+1)/2)-int(F1*L/2))+(0*((F1*L+1)*(int((F1*L+1)/2)-int(F1*L/2))+(F1*L+0)*(int((F1*L+2)/2)-int((F1*L+1)/2))))*(int((F1*L+2)/2)-int((F1*L+1)/2))))*1.5e-06+((0*((F1*L-1)/2+1-0))*(int((F1*L+1)/2)-int(F1*L/2))+(0*int(F1*L/2))*(int((F1*L+2)/2)-int((F1*L+1)/2)))*4)/F1*L \
        ps=(((4.8e-07+((F1*L-1)*5.4e-07)/2+0)*(int((F1*L+1)/2)-int(F1*L/2))+(4.8e-07+4.8e-07+(int(F1*L/2)-1)*5.4e-07+0+0)*(int((F1*L+2)/2)-int((F1*L+1)/2)))*2+(((F1*L+1)*(int((F1*L+1)/2)-int(F1*L/2))+(F1*L+2)*(int((F1*L+2)/2)-int((F1*L+1)/2)))-((0*(((F1*L+1)*(int((F1*L+1)/2)-int(F1*L/2))+(F1*L+2)*(int((F1*L+2)/2)-int((F1*L+1)/2)))-0))*(int((F1*L+1)/2)-int(F1*L/2))+(0*(((F1*L+1)*(int((F1*L+1)/2)-int(F1*L/2))+(F1*L+2)*(int((F1*L+2)/2)-int((F1*L+1)/2)))-0-0))*(int((F1*L+2)/2)-int((F1*L+1)/2))))*1.5e-06+((0*((F1*L-1)/2+1-0))*(int((F1*L+1)/2)-int(F1*L/2))+(0*(int(F1*L/2)+1-0-0))*(int((F1*L+2)/2)-int((F1*L+1)/2)))*4)/F1*L \
        nrd=(5.4e-07+2.7e-07*(F1*2-2))/F1/(1.5e-06*2) \
        nrs=(5.4e-07+2.7e-07*(F1*2-2))/F1/(1.5e-06*2)
    M133 (net44 CLKFIA AVDD AVDD) pch_mis l=180.0n w=WK multi=(2) \
        ad=(WK*((4.8e-07+((2-1)*5.4e-07)/2+0)*(int((2+1)/2)-int(2/2))+(2/2)*5.4e-07*(int((2+2)/2)-int((2+1)/2)))+((0*0*((2-1)/2+1-0))*(int((2+1)/2)-int(2/2))+(0*0*int(2/2))*(int((2+2)/2)-int((2+1)/2))))/2 \
        as=(WK*((4.8e-07+((2-1)*5.4e-07)/2+0)*(int((2+1)/2)-int(2/2))+(4.8e-07+4.8e-07+(int(2/2)-1)*5.4e-07+0+0)*(int((2+2)/2)-int((2+1)/2)))+((0*0*((2-1)/2+1-0))*(int((2+1)/2)-int(2/2))+(0*0*(int(2/2)+1-0-0))*(int((2+2)/2)-int((2+1)/2))))/2 \
        pd=(((4.8e-07+((2-1)*5.4e-07)/2+0)*(int((2+1)/2)-int(2/2))+(2/2)*5.4e-07*(int((2+2)/2)-int((2+1)/2)))*2+(((2+1)*(int((2+1)/2)-int(2/2))+(2+0)*(int((2+2)/2)-int((2+1)/2)))-((0*(((2+1)*(int((2+1)/2)-int(2/2))+(2+0)*(int((2+2)/2)-int((2+1)/2)))-0))*(int((2+1)/2)-int(2/2))+(0*((2+1)*(int((2+1)/2)-int(2/2))+(2+0)*(int((2+2)/2)-int((2+1)/2))))*(int((2+2)/2)-int((2+1)/2))))*WK+((0*((2-1)/2+1-0))*(int((2+1)/2)-int(2/2))+(0*int(2/2))*(int((2+2)/2)-int((2+1)/2)))*4)/2 \
        ps=(((4.8e-07+((2-1)*5.4e-07)/2+0)*(int((2+1)/2)-int(2/2))+(4.8e-07+4.8e-07+(int(2/2)-1)*5.4e-07+0+0)*(int((2+2)/2)-int((2+1)/2)))*2+(((2+1)*(int((2+1)/2)-int(2/2))+(2+2)*(int((2+2)/2)-int((2+1)/2)))-((0*(((2+1)*(int((2+1)/2)-int(2/2))+(2+2)*(int((2+2)/2)-int((2+1)/2)))-0))*(int((2+1)/2)-int(2/2))+(0*(((2+1)*(int((2+1)/2)-int(2/2))+(2+2)*(int((2+2)/2)-int((2+1)/2)))-0-0))*(int((2+2)/2)-int((2+1)/2))))*WK+((0*((2-1)/2+1-0))*(int((2+1)/2)-int(2/2))+(0*(int(2/2)+1-0-0))*(int((2+2)/2)-int((2+1)/2)))*4)/2 \
        nrd=(5.4e-07+2.7e-07*(2*2-2))/2/(WK*2) \
        nrs=(5.4e-07+2.7e-07*(2*2-2))/2/(WK*2)
    M132 (net44 CLKFIAB V1 AVDD) pch_mis l=180.0n w=WK1 multi=(2) \
        ad=(WK1*((4.8e-07+((2-1)*5.4e-07)/2+0)*(int((2+1)/2)-int(2/2))+(2/2)*5.4e-07*(int((2+2)/2)-int((2+1)/2)))+((0*0*((2-1)/2+1-0))*(int((2+1)/2)-int(2/2))+(0*0*int(2/2))*(int((2+2)/2)-int((2+1)/2))))/2 \
        as=(WK1*((4.8e-07+((2-1)*5.4e-07)/2+0)*(int((2+1)/2)-int(2/2))+(4.8e-07+4.8e-07+(int(2/2)-1)*5.4e-07+0+0)*(int((2+2)/2)-int((2+1)/2)))+((0*0*((2-1)/2+1-0))*(int((2+1)/2)-int(2/2))+(0*0*(int(2/2)+1-0-0))*(int((2+2)/2)-int((2+1)/2))))/2 \
        pd=(((4.8e-07+((2-1)*5.4e-07)/2+0)*(int((2+1)/2)-int(2/2))+(2/2)*5.4e-07*(int((2+2)/2)-int((2+1)/2)))*2+(((2+1)*(int((2+1)/2)-int(2/2))+(2+0)*(int((2+2)/2)-int((2+1)/2)))-((0*(((2+1)*(int((2+1)/2)-int(2/2))+(2+0)*(int((2+2)/2)-int((2+1)/2)))-0))*(int((2+1)/2)-int(2/2))+(0*((2+1)*(int((2+1)/2)-int(2/2))+(2+0)*(int((2+2)/2)-int((2+1)/2))))*(int((2+2)/2)-int((2+1)/2))))*WK1+((0*((2-1)/2+1-0))*(int((2+1)/2)-int(2/2))+(0*int(2/2))*(int((2+2)/2)-int((2+1)/2)))*4)/2 \
        ps=(((4.8e-07+((2-1)*5.4e-07)/2+0)*(int((2+1)/2)-int(2/2))+(4.8e-07+4.8e-07+(int(2/2)-1)*5.4e-07+0+0)*(int((2+2)/2)-int((2+1)/2)))*2+(((2+1)*(int((2+1)/2)-int(2/2))+(2+2)*(int((2+2)/2)-int((2+1)/2)))-((0*(((2+1)*(int((2+1)/2)-int(2/2))+(2+2)*(int((2+2)/2)-int((2+1)/2)))-0))*(int((2+1)/2)-int(2/2))+(0*(((2+1)*(int((2+1)/2)-int(2/2))+(2+2)*(int((2+2)/2)-int((2+1)/2)))-0-0))*(int((2+2)/2)-int((2+1)/2))))*WK1+((0*((2-1)/2+1-0))*(int((2+1)/2)-int(2/2))+(0*(int(2/2)+1-0-0))*(int((2+2)/2)-int((2+1)/2)))*4)/2 \
        nrd=(5.4e-07+2.7e-07*(2*2-2))/2/(WK1*2) \
        nrs=(5.4e-07+2.7e-07*(2*2-2))/2/(WK1*2)
    M131 (net43 VIN V1 AVDD) pch_mis l=180.0n w=4u multi=(1*F3) \
        ad=(4e-06*((4.8e-07+((F3-1)*5.4e-07)/2+0)*(int((F3+1)/2)-int(F3/2))+(F3/2)*5.4e-07*(int((F3+2)/2)-int((F3+1)/2)))+((0*0*((F3-1)/2+1-0))*(int((F3+1)/2)-int(F3/2))+(0*0*int(F3/2))*(int((F3+2)/2)-int((F3+1)/2))))/F3 \
        as=(4e-06*((4.8e-07+((F3-1)*5.4e-07)/2+0)*(int((F3+1)/2)-int(F3/2))+(4.8e-07+4.8e-07+(int(F3/2)-1)*5.4e-07+0+0)*(int((F3+2)/2)-int((F3+1)/2)))+((0*0*((F3-1)/2+1-0))*(int((F3+1)/2)-int(F3/2))+(0*0*(int(F3/2)+1-0-0))*(int((F3+2)/2)-int((F3+1)/2))))/F3 \
        pd=(((4.8e-07+((F3-1)*5.4e-07)/2+0)*(int((F3+1)/2)-int(F3/2))+(F3/2)*5.4e-07*(int((F3+2)/2)-int((F3+1)/2)))*2+(((F3+1)*(int((F3+1)/2)-int(F3/2))+(F3+0)*(int((F3+2)/2)-int((F3+1)/2)))-((0*(((F3+1)*(int((F3+1)/2)-int(F3/2))+(F3+0)*(int((F3+2)/2)-int((F3+1)/2)))-0))*(int((F3+1)/2)-int(F3/2))+(0*((F3+1)*(int((F3+1)/2)-int(F3/2))+(F3+0)*(int((F3+2)/2)-int((F3+1)/2))))*(int((F3+2)/2)-int((F3+1)/2))))*4e-06+((0*((F3-1)/2+1-0))*(int((F3+1)/2)-int(F3/2))+(0*int(F3/2))*(int((F3+2)/2)-int((F3+1)/2)))*4)/F3 \
        ps=(((4.8e-07+((F3-1)*5.4e-07)/2+0)*(int((F3+1)/2)-int(F3/2))+(4.8e-07+4.8e-07+(int(F3/2)-1)*5.4e-07+0+0)*(int((F3+2)/2)-int((F3+1)/2)))*2+(((F3+1)*(int((F3+1)/2)-int(F3/2))+(F3+2)*(int((F3+2)/2)-int((F3+1)/2)))-((0*(((F3+1)*(int((F3+1)/2)-int(F3/2))+(F3+2)*(int((F3+2)/2)-int((F3+1)/2)))-0))*(int((F3+1)/2)-int(F3/2))+(0*(((F3+1)*(int((F3+1)/2)-int(F3/2))+(F3+2)*(int((F3+2)/2)-int((F3+1)/2)))-0-0))*(int((F3+2)/2)-int((F3+1)/2))))*4e-06+((0*((F3-1)/2+1-0))*(int((F3+1)/2)-int(F3/2))+(0*(int(F3/2)+1-0-0))*(int((F3+2)/2)-int((F3+1)/2)))*4)/F3 \
        nrd=(5.4e-07+2.7e-07*(F3*2-2))/F3/(4e-06*2) \
        nrs=(5.4e-07+2.7e-07*(F3*2-2))/F3/(4e-06*2)
    M130 (net13637 VIP V1 AVDD) pch_mis l=180.0n w=4u multi=(1*F3) \
        ad=(4e-06*((4.8e-07+((F3-1)*5.4e-07)/2+0)*(int((F3+1)/2)-int(F3/2))+(F3/2)*5.4e-07*(int((F3+2)/2)-int((F3+1)/2)))+((0*0*((F3-1)/2+1-0))*(int((F3+1)/2)-int(F3/2))+(0*0*int(F3/2))*(int((F3+2)/2)-int((F3+1)/2))))/F3 \
        as=(4e-06*((4.8e-07+((F3-1)*5.4e-07)/2+0)*(int((F3+1)/2)-int(F3/2))+(4.8e-07+4.8e-07+(int(F3/2)-1)*5.4e-07+0+0)*(int((F3+2)/2)-int((F3+1)/2)))+((0*0*((F3-1)/2+1-0))*(int((F3+1)/2)-int(F3/2))+(0*0*(int(F3/2)+1-0-0))*(int((F3+2)/2)-int((F3+1)/2))))/F3 \
        pd=(((4.8e-07+((F3-1)*5.4e-07)/2+0)*(int((F3+1)/2)-int(F3/2))+(F3/2)*5.4e-07*(int((F3+2)/2)-int((F3+1)/2)))*2+(((F3+1)*(int((F3+1)/2)-int(F3/2))+(F3+0)*(int((F3+2)/2)-int((F3+1)/2)))-((0*(((F3+1)*(int((F3+1)/2)-int(F3/2))+(F3+0)*(int((F3+2)/2)-int((F3+1)/2)))-0))*(int((F3+1)/2)-int(F3/2))+(0*((F3+1)*(int((F3+1)/2)-int(F3/2))+(F3+0)*(int((F3+2)/2)-int((F3+1)/2))))*(int((F3+2)/2)-int((F3+1)/2))))*4e-06+((0*((F3-1)/2+1-0))*(int((F3+1)/2)-int(F3/2))+(0*int(F3/2))*(int((F3+2)/2)-int((F3+1)/2)))*4)/F3 \
        ps=(((4.8e-07+((F3-1)*5.4e-07)/2+0)*(int((F3+1)/2)-int(F3/2))+(4.8e-07+4.8e-07+(int(F3/2)-1)*5.4e-07+0+0)*(int((F3+2)/2)-int((F3+1)/2)))*2+(((F3+1)*(int((F3+1)/2)-int(F3/2))+(F3+2)*(int((F3+2)/2)-int((F3+1)/2)))-((0*(((F3+1)*(int((F3+1)/2)-int(F3/2))+(F3+2)*(int((F3+2)/2)-int((F3+1)/2)))-0))*(int((F3+1)/2)-int(F3/2))+(0*(((F3+1)*(int((F3+1)/2)-int(F3/2))+(F3+2)*(int((F3+2)/2)-int((F3+1)/2)))-0-0))*(int((F3+2)/2)-int((F3+1)/2))))*4e-06+((0*((F3-1)/2+1-0))*(int((F3+1)/2)-int(F3/2))+(0*(int(F3/2)+1-0-0))*(int((F3+2)/2)-int((F3+1)/2)))*4)/F3 \
        nrd=(5.4e-07+2.7e-07*(F3*2-2))/F3/(4e-06*2) \
        nrs=(5.4e-07+2.7e-07*(F3*2-2))/F3/(4e-06*2)
    M129 (VON1 AGND net43 AVDD) pch_mis l=180.0n w=4u multi=(1*F3) \
        ad=(4e-06*((4.8e-07+((F3-1)*5.4e-07)/2+0)*(int((F3+1)/2)-int(F3/2))+(F3/2)*5.4e-07*(int((F3+2)/2)-int((F3+1)/2)))+((0*0*((F3-1)/2+1-0))*(int((F3+1)/2)-int(F3/2))+(0*0*int(F3/2))*(int((F3+2)/2)-int((F3+1)/2))))/F3 \
        as=(4e-06*((4.8e-07+((F3-1)*5.4e-07)/2+0)*(int((F3+1)/2)-int(F3/2))+(4.8e-07+4.8e-07+(int(F3/2)-1)*5.4e-07+0+0)*(int((F3+2)/2)-int((F3+1)/2)))+((0*0*((F3-1)/2+1-0))*(int((F3+1)/2)-int(F3/2))+(0*0*(int(F3/2)+1-0-0))*(int((F3+2)/2)-int((F3+1)/2))))/F3 \
        pd=(((4.8e-07+((F3-1)*5.4e-07)/2+0)*(int((F3+1)/2)-int(F3/2))+(F3/2)*5.4e-07*(int((F3+2)/2)-int((F3+1)/2)))*2+(((F3+1)*(int((F3+1)/2)-int(F3/2))+(F3+0)*(int((F3+2)/2)-int((F3+1)/2)))-((0*(((F3+1)*(int((F3+1)/2)-int(F3/2))+(F3+0)*(int((F3+2)/2)-int((F3+1)/2)))-0))*(int((F3+1)/2)-int(F3/2))+(0*((F3+1)*(int((F3+1)/2)-int(F3/2))+(F3+0)*(int((F3+2)/2)-int((F3+1)/2))))*(int((F3+2)/2)-int((F3+1)/2))))*4e-06+((0*((F3-1)/2+1-0))*(int((F3+1)/2)-int(F3/2))+(0*int(F3/2))*(int((F3+2)/2)-int((F3+1)/2)))*4)/F3 \
        ps=(((4.8e-07+((F3-1)*5.4e-07)/2+0)*(int((F3+1)/2)-int(F3/2))+(4.8e-07+4.8e-07+(int(F3/2)-1)*5.4e-07+0+0)*(int((F3+2)/2)-int((F3+1)/2)))*2+(((F3+1)*(int((F3+1)/2)-int(F3/2))+(F3+2)*(int((F3+2)/2)-int((F3+1)/2)))-((0*(((F3+1)*(int((F3+1)/2)-int(F3/2))+(F3+2)*(int((F3+2)/2)-int((F3+1)/2)))-0))*(int((F3+1)/2)-int(F3/2))+(0*(((F3+1)*(int((F3+1)/2)-int(F3/2))+(F3+2)*(int((F3+2)/2)-int((F3+1)/2)))-0-0))*(int((F3+2)/2)-int((F3+1)/2))))*4e-06+((0*((F3-1)/2+1-0))*(int((F3+1)/2)-int(F3/2))+(0*(int(F3/2)+1-0-0))*(int((F3+2)/2)-int((F3+1)/2)))*4)/F3 \
        nrd=(5.4e-07+2.7e-07*(F3*2-2))/F3/(4e-06*2) \
        nrs=(5.4e-07+2.7e-07*(F3*2-2))/F3/(4e-06*2)
    M128 (VOP1 AGND net13637 AVDD) pch_mis l=180.0n w=4u multi=(1*F3) \
        ad=(4e-06*((4.8e-07+((F3-1)*5.4e-07)/2+0)*(int((F3+1)/2)-int(F3/2))+(F3/2)*5.4e-07*(int((F3+2)/2)-int((F3+1)/2)))+((0*0*((F3-1)/2+1-0))*(int((F3+1)/2)-int(F3/2))+(0*0*int(F3/2))*(int((F3+2)/2)-int((F3+1)/2))))/F3 \
        as=(4e-06*((4.8e-07+((F3-1)*5.4e-07)/2+0)*(int((F3+1)/2)-int(F3/2))+(4.8e-07+4.8e-07+(int(F3/2)-1)*5.4e-07+0+0)*(int((F3+2)/2)-int((F3+1)/2)))+((0*0*((F3-1)/2+1-0))*(int((F3+1)/2)-int(F3/2))+(0*0*(int(F3/2)+1-0-0))*(int((F3+2)/2)-int((F3+1)/2))))/F3 \
        pd=(((4.8e-07+((F3-1)*5.4e-07)/2+0)*(int((F3+1)/2)-int(F3/2))+(F3/2)*5.4e-07*(int((F3+2)/2)-int((F3+1)/2)))*2+(((F3+1)*(int((F3+1)/2)-int(F3/2))+(F3+0)*(int((F3+2)/2)-int((F3+1)/2)))-((0*(((F3+1)*(int((F3+1)/2)-int(F3/2))+(F3+0)*(int((F3+2)/2)-int((F3+1)/2)))-0))*(int((F3+1)/2)-int(F3/2))+(0*((F3+1)*(int((F3+1)/2)-int(F3/2))+(F3+0)*(int((F3+2)/2)-int((F3+1)/2))))*(int((F3+2)/2)-int((F3+1)/2))))*4e-06+((0*((F3-1)/2+1-0))*(int((F3+1)/2)-int(F3/2))+(0*int(F3/2))*(int((F3+2)/2)-int((F3+1)/2)))*4)/F3 \
        ps=(((4.8e-07+((F3-1)*5.4e-07)/2+0)*(int((F3+1)/2)-int(F3/2))+(4.8e-07+4.8e-07+(int(F3/2)-1)*5.4e-07+0+0)*(int((F3+2)/2)-int((F3+1)/2)))*2+(((F3+1)*(int((F3+1)/2)-int(F3/2))+(F3+2)*(int((F3+2)/2)-int((F3+1)/2)))-((0*(((F3+1)*(int((F3+1)/2)-int(F3/2))+(F3+2)*(int((F3+2)/2)-int((F3+1)/2)))-0))*(int((F3+1)/2)-int(F3/2))+(0*(((F3+1)*(int((F3+1)/2)-int(F3/2))+(F3+2)*(int((F3+2)/2)-int((F3+1)/2)))-0-0))*(int((F3+2)/2)-int((F3+1)/2))))*4e-06+((0*((F3-1)/2+1-0))*(int((F3+1)/2)-int(F3/2))+(0*(int(F3/2)+1-0-0))*(int((F3+2)/2)-int((F3+1)/2)))*4)/F3 \
        nrd=(5.4e-07+2.7e-07*(F3*2-2))/F3/(4e-06*2) \
        nrs=(5.4e-07+2.7e-07*(F3*2-2))/F3/(4e-06*2)
    M97 (net11 CLKB1 AVDD AVDD) pch_mis l=180.0n w=250.0n multi=(1*FM7) \
        ad=(2.5e-07*((1e-07+((FM7-1)*2e-07)/2+0)*(int((FM7+1)/2)-int(FM7/2))+(FM7/2)*2e-07*(int((FM7+2)/2)-int((FM7+1)/2)))+((4.2e-07*4.2e-07*((FM7-1)/2+1-0))*(int((FM7+1)/2)-int(FM7/2))+(4.2e-07*4.2e-07*int(FM7/2))*(int((FM7+2)/2)-int((FM7+1)/2))))/FM7 \
        as=(2.5e-07*((1e-07+((FM7-1)*2e-07)/2+0)*(int((FM7+1)/2)-int(FM7/2))+(1e-07+1e-07+(int(FM7/2)-1)*2e-07+0+0)*(int((FM7+2)/2)-int((FM7+1)/2)))+((4.2e-07*4.2e-07*((FM7-1)/2+1-0))*(int((FM7+1)/2)-int(FM7/2))+(4.2e-07*4.2e-07*(int(FM7/2)+1-0-0))*(int((FM7+2)/2)-int((FM7+1)/2))))/FM7 \
        pd=(((1e-07+((FM7-1)*2e-07)/2+0)*(int((FM7+1)/2)-int(FM7/2))+(FM7/2)*2e-07*(int((FM7+2)/2)-int((FM7+1)/2)))*2+(((FM7+1)*(int((FM7+1)/2)-int(FM7/2))+(FM7+0)*(int((FM7+2)/2)-int((FM7+1)/2)))-((1*(((FM7+1)*(int((FM7+1)/2)-int(FM7/2))+(FM7+0)*(int((FM7+2)/2)-int((FM7+1)/2)))-0))*(int((FM7+1)/2)-int(FM7/2))+(1*((FM7+1)*(int((FM7+1)/2)-int(FM7/2))+(FM7+0)*(int((FM7+2)/2)-int((FM7+1)/2))))*(int((FM7+2)/2)-int((FM7+1)/2))))*2.5e-07+((4.2e-07*((FM7-1)/2+1-0))*(int((FM7+1)/2)-int(FM7/2))+(4.2e-07*int(FM7/2))*(int((FM7+2)/2)-int((FM7+1)/2)))*4)/FM7 \
        ps=(((1e-07+((FM7-1)*2e-07)/2+0)*(int((FM7+1)/2)-int(FM7/2))+(1e-07+1e-07+(int(FM7/2)-1)*2e-07+0+0)*(int((FM7+2)/2)-int((FM7+1)/2)))*2+(((FM7+1)*(int((FM7+1)/2)-int(FM7/2))+(FM7+2)*(int((FM7+2)/2)-int((FM7+1)/2)))-((1*(((FM7+1)*(int((FM7+1)/2)-int(FM7/2))+(FM7+2)*(int((FM7+2)/2)-int((FM7+1)/2)))-0))*(int((FM7+1)/2)-int(FM7/2))+(1*(((FM7+1)*(int((FM7+1)/2)-int(FM7/2))+(FM7+2)*(int((FM7+2)/2)-int((FM7+1)/2)))-0-0))*(int((FM7+2)/2)-int((FM7+1)/2))))*2.5e-07+((4.2e-07*((FM7-1)/2+1-0))*(int((FM7+1)/2)-int(FM7/2))+(4.2e-07*(int(FM7/2)+1-0-0))*(int((FM7+2)/2)-int((FM7+1)/2)))*4)/FM7 \
        nrd=(6.2e-07+3.1e-07*(FM7*2-2))/FM7/(2.5e-07*2) \
        nrs=(6.2e-07+3.1e-07*(FM7*2-2))/FM7/(2.5e-07*2)
    M81 (net13016 VOP1 net11 AVDD) pch_mis l=180.0n w=2u multi=(1*FSR) \
        ad=(2e-06*((4.8e-07+((FSR-1)*5.4e-07)/2+0)*(int((FSR+1)/2)-int(FSR/2))+(FSR/2)*5.4e-07*(int((FSR+2)/2)-int((FSR+1)/2)))+((0*0*((FSR-1)/2+1-0))*(int((FSR+1)/2)-int(FSR/2))+(0*0*int(FSR/2))*(int((FSR+2)/2)-int((FSR+1)/2))))/FSR \
        as=(2e-06*((4.8e-07+((FSR-1)*5.4e-07)/2+0)*(int((FSR+1)/2)-int(FSR/2))+(4.8e-07+4.8e-07+(int(FSR/2)-1)*5.4e-07+0+0)*(int((FSR+2)/2)-int((FSR+1)/2)))+((0*0*((FSR-1)/2+1-0))*(int((FSR+1)/2)-int(FSR/2))+(0*0*(int(FSR/2)+1-0-0))*(int((FSR+2)/2)-int((FSR+1)/2))))/FSR \
        pd=(((4.8e-07+((FSR-1)*5.4e-07)/2+0)*(int((FSR+1)/2)-int(FSR/2))+(FSR/2)*5.4e-07*(int((FSR+2)/2)-int((FSR+1)/2)))*2+(((FSR+1)*(int((FSR+1)/2)-int(FSR/2))+(FSR+0)*(int((FSR+2)/2)-int((FSR+1)/2)))-((0*(((FSR+1)*(int((FSR+1)/2)-int(FSR/2))+(FSR+0)*(int((FSR+2)/2)-int((FSR+1)/2)))-0))*(int((FSR+1)/2)-int(FSR/2))+(0*((FSR+1)*(int((FSR+1)/2)-int(FSR/2))+(FSR+0)*(int((FSR+2)/2)-int((FSR+1)/2))))*(int((FSR+2)/2)-int((FSR+1)/2))))*2e-06+((0*((FSR-1)/2+1-0))*(int((FSR+1)/2)-int(FSR/2))+(0*int(FSR/2))*(int((FSR+2)/2)-int((FSR+1)/2)))*4)/FSR \
        ps=(((4.8e-07+((FSR-1)*5.4e-07)/2+0)*(int((FSR+1)/2)-int(FSR/2))+(4.8e-07+4.8e-07+(int(FSR/2)-1)*5.4e-07+0+0)*(int((FSR+2)/2)-int((FSR+1)/2)))*2+(((FSR+1)*(int((FSR+1)/2)-int(FSR/2))+(FSR+2)*(int((FSR+2)/2)-int((FSR+1)/2)))-((0*(((FSR+1)*(int((FSR+1)/2)-int(FSR/2))+(FSR+2)*(int((FSR+2)/2)-int((FSR+1)/2)))-0))*(int((FSR+1)/2)-int(FSR/2))+(0*(((FSR+1)*(int((FSR+1)/2)-int(FSR/2))+(FSR+2)*(int((FSR+2)/2)-int((FSR+1)/2)))-0-0))*(int((FSR+2)/2)-int((FSR+1)/2))))*2e-06+((0*((FSR-1)/2+1-0))*(int((FSR+1)/2)-int(FSR/2))+(0*(int(FSR/2)+1-0-0))*(int((FSR+2)/2)-int((FSR+1)/2)))*4)/FSR \
        nrd=(5.4e-07+2.7e-07*(FSR*2-2))/FSR/(2e-06*2) \
        nrs=(5.4e-07+2.7e-07*(FSR*2-2))/FSR/(2e-06*2)
    M80 (net13028 VON1 net11 AVDD) pch_mis l=180.0n w=2u multi=(1*FSR) \
        ad=(2e-06*((4.8e-07+((FSR-1)*5.4e-07)/2+0)*(int((FSR+1)/2)-int(FSR/2))+(FSR/2)*5.4e-07*(int((FSR+2)/2)-int((FSR+1)/2)))+((0*0*((FSR-1)/2+1-0))*(int((FSR+1)/2)-int(FSR/2))+(0*0*int(FSR/2))*(int((FSR+2)/2)-int((FSR+1)/2))))/FSR \
        as=(2e-06*((4.8e-07+((FSR-1)*5.4e-07)/2+0)*(int((FSR+1)/2)-int(FSR/2))+(4.8e-07+4.8e-07+(int(FSR/2)-1)*5.4e-07+0+0)*(int((FSR+2)/2)-int((FSR+1)/2)))+((0*0*((FSR-1)/2+1-0))*(int((FSR+1)/2)-int(FSR/2))+(0*0*(int(FSR/2)+1-0-0))*(int((FSR+2)/2)-int((FSR+1)/2))))/FSR \
        pd=(((4.8e-07+((FSR-1)*5.4e-07)/2+0)*(int((FSR+1)/2)-int(FSR/2))+(FSR/2)*5.4e-07*(int((FSR+2)/2)-int((FSR+1)/2)))*2+(((FSR+1)*(int((FSR+1)/2)-int(FSR/2))+(FSR+0)*(int((FSR+2)/2)-int((FSR+1)/2)))-((0*(((FSR+1)*(int((FSR+1)/2)-int(FSR/2))+(FSR+0)*(int((FSR+2)/2)-int((FSR+1)/2)))-0))*(int((FSR+1)/2)-int(FSR/2))+(0*((FSR+1)*(int((FSR+1)/2)-int(FSR/2))+(FSR+0)*(int((FSR+2)/2)-int((FSR+1)/2))))*(int((FSR+2)/2)-int((FSR+1)/2))))*2e-06+((0*((FSR-1)/2+1-0))*(int((FSR+1)/2)-int(FSR/2))+(0*int(FSR/2))*(int((FSR+2)/2)-int((FSR+1)/2)))*4)/FSR \
        ps=(((4.8e-07+((FSR-1)*5.4e-07)/2+0)*(int((FSR+1)/2)-int(FSR/2))+(4.8e-07+4.8e-07+(int(FSR/2)-1)*5.4e-07+0+0)*(int((FSR+2)/2)-int((FSR+1)/2)))*2+(((FSR+1)*(int((FSR+1)/2)-int(FSR/2))+(FSR+2)*(int((FSR+2)/2)-int((FSR+1)/2)))-((0*(((FSR+1)*(int((FSR+1)/2)-int(FSR/2))+(FSR+2)*(int((FSR+2)/2)-int((FSR+1)/2)))-0))*(int((FSR+1)/2)-int(FSR/2))+(0*(((FSR+1)*(int((FSR+1)/2)-int(FSR/2))+(FSR+2)*(int((FSR+2)/2)-int((FSR+1)/2)))-0-0))*(int((FSR+2)/2)-int((FSR+1)/2))))*2e-06+((0*((FSR-1)/2+1-0))*(int((FSR+1)/2)-int(FSR/2))+(0*(int(FSR/2)+1-0-0))*(int((FSR+2)/2)-int((FSR+1)/2)))*4)/FSR \
        nrd=(5.4e-07+2.7e-07*(FSR*2-2))/FSR/(2e-06*2) \
        nrs=(5.4e-07+2.7e-07*(FSR*2-2))/FSR/(2e-06*2)
    I295 (net3 CLKAZ AVDD AGND) INVX2
    I230 (net5 VOP AVDD AGND) INVX2
    I226 (net4 VON AVDD AGND) INVX2
    M127 (VON1 AVDD net40 AGND) nch_mis l=180.0n w=2u multi=(1*F4) \
        ad=(2e-06*((4.8e-07+((F4-1)*5.4e-07)/2+0)*(int((F4+1)/2)-int(F4/2))+(F4/2)*5.4e-07*(int((F4+2)/2)-int((F4+1)/2)))+((0*0*((F4-1)/2+1-0))*(int((F4+1)/2)-int(F4/2))+(0*0*int(F4/2))*(int((F4+2)/2)-int((F4+1)/2))))/F4 \
        as=(2e-06*((4.8e-07+((F4-1)*5.4e-07)/2+0)*(int((F4+1)/2)-int(F4/2))+(4.8e-07+4.8e-07+(int(F4/2)-1)*5.4e-07+0+0)*(int((F4+2)/2)-int((F4+1)/2)))+((0*0*((F4-1)/2+1-0))*(int((F4+1)/2)-int(F4/2))+(0*0*(int(F4/2)+1-0-0))*(int((F4+2)/2)-int((F4+1)/2))))/F4 \
        pd=(((4.8e-07+((F4-1)*5.4e-07)/2+0)*(int((F4+1)/2)-int(F4/2))+(F4/2)*5.4e-07*(int((F4+2)/2)-int((F4+1)/2)))*2+(((F4+1)*(int((F4+1)/2)-int(F4/2))+(F4+0)*(int((F4+2)/2)-int((F4+1)/2)))-((0*(((F4+1)*(int((F4+1)/2)-int(F4/2))+(F4+0)*(int((F4+2)/2)-int((F4+1)/2)))-0))*(int((F4+1)/2)-int(F4/2))+(0*((F4+1)*(int((F4+1)/2)-int(F4/2))+(F4+0)*(int((F4+2)/2)-int((F4+1)/2))))*(int((F4+2)/2)-int((F4+1)/2))))*2e-06+((0*((F4-1)/2+1-0))*(int((F4+1)/2)-int(F4/2))+(0*int(F4/2))*(int((F4+2)/2)-int((F4+1)/2)))*4)/F4 \
        ps=(((4.8e-07+((F4-1)*5.4e-07)/2+0)*(int((F4+1)/2)-int(F4/2))+(4.8e-07+4.8e-07+(int(F4/2)-1)*5.4e-07+0+0)*(int((F4+2)/2)-int((F4+1)/2)))*2+(((F4+1)*(int((F4+1)/2)-int(F4/2))+(F4+2)*(int((F4+2)/2)-int((F4+1)/2)))-((0*(((F4+1)*(int((F4+1)/2)-int(F4/2))+(F4+2)*(int((F4+2)/2)-int((F4+1)/2)))-0))*(int((F4+1)/2)-int(F4/2))+(0*(((F4+1)*(int((F4+1)/2)-int(F4/2))+(F4+2)*(int((F4+2)/2)-int((F4+1)/2)))-0-0))*(int((F4+2)/2)-int((F4+1)/2))))*2e-06+((0*((F4-1)/2+1-0))*(int((F4+1)/2)-int(F4/2))+(0*(int(F4/2)+1-0-0))*(int((F4+2)/2)-int((F4+1)/2)))*4)/F4 \
        nrd=(5.4e-07+2.7e-07*(F4*2-2))/F4/(2e-06*2) \
        nrs=(5.4e-07+2.7e-07*(F4*2-2))/F4/(2e-06*2)
    M126 (VOP1 AVDD net13605 AGND) nch_mis l=180.0n w=2u multi=(1*F4) \
        ad=(2e-06*((4.8e-07+((F4-1)*5.4e-07)/2+0)*(int((F4+1)/2)-int(F4/2))+(F4/2)*5.4e-07*(int((F4+2)/2)-int((F4+1)/2)))+((0*0*((F4-1)/2+1-0))*(int((F4+1)/2)-int(F4/2))+(0*0*int(F4/2))*(int((F4+2)/2)-int((F4+1)/2))))/F4 \
        as=(2e-06*((4.8e-07+((F4-1)*5.4e-07)/2+0)*(int((F4+1)/2)-int(F4/2))+(4.8e-07+4.8e-07+(int(F4/2)-1)*5.4e-07+0+0)*(int((F4+2)/2)-int((F4+1)/2)))+((0*0*((F4-1)/2+1-0))*(int((F4+1)/2)-int(F4/2))+(0*0*(int(F4/2)+1-0-0))*(int((F4+2)/2)-int((F4+1)/2))))/F4 \
        pd=(((4.8e-07+((F4-1)*5.4e-07)/2+0)*(int((F4+1)/2)-int(F4/2))+(F4/2)*5.4e-07*(int((F4+2)/2)-int((F4+1)/2)))*2+(((F4+1)*(int((F4+1)/2)-int(F4/2))+(F4+0)*(int((F4+2)/2)-int((F4+1)/2)))-((0*(((F4+1)*(int((F4+1)/2)-int(F4/2))+(F4+0)*(int((F4+2)/2)-int((F4+1)/2)))-0))*(int((F4+1)/2)-int(F4/2))+(0*((F4+1)*(int((F4+1)/2)-int(F4/2))+(F4+0)*(int((F4+2)/2)-int((F4+1)/2))))*(int((F4+2)/2)-int((F4+1)/2))))*2e-06+((0*((F4-1)/2+1-0))*(int((F4+1)/2)-int(F4/2))+(0*int(F4/2))*(int((F4+2)/2)-int((F4+1)/2)))*4)/F4 \
        ps=(((4.8e-07+((F4-1)*5.4e-07)/2+0)*(int((F4+1)/2)-int(F4/2))+(4.8e-07+4.8e-07+(int(F4/2)-1)*5.4e-07+0+0)*(int((F4+2)/2)-int((F4+1)/2)))*2+(((F4+1)*(int((F4+1)/2)-int(F4/2))+(F4+2)*(int((F4+2)/2)-int((F4+1)/2)))-((0*(((F4+1)*(int((F4+1)/2)-int(F4/2))+(F4+2)*(int((F4+2)/2)-int((F4+1)/2)))-0))*(int((F4+1)/2)-int(F4/2))+(0*(((F4+1)*(int((F4+1)/2)-int(F4/2))+(F4+2)*(int((F4+2)/2)-int((F4+1)/2)))-0-0))*(int((F4+2)/2)-int((F4+1)/2))))*2e-06+((0*((F4-1)/2+1-0))*(int((F4+1)/2)-int(F4/2))+(0*(int(F4/2)+1-0-0))*(int((F4+2)/2)-int((F4+1)/2)))*4)/F4 \
        nrd=(5.4e-07+2.7e-07*(F4*2-2))/F4/(2e-06*2) \
        nrs=(5.4e-07+2.7e-07*(F4*2-2))/F4/(2e-06*2)
    M125 (net41 CLKFIA V2 AGND) nch_mis l=180.0n w=WK1 multi=(1) \
        ad=(WK1*((4.8e-07+((1-1)*5.4e-07)/2+0)*(int((1+1)/2)-int(1/2))+(1/2)*5.4e-07*(int((1+2)/2)-int((1+1)/2)))+((0*0*((1-1)/2+1-0))*(int((1+1)/2)-int(1/2))+(0*0*int(1/2))*(int((1+2)/2)-int((1+1)/2))))/1 \
        as=(WK1*((4.8e-07+((1-1)*5.4e-07)/2+0)*(int((1+1)/2)-int(1/2))+(4.8e-07+4.8e-07+(int(1/2)-1)*5.4e-07+0+0)*(int((1+2)/2)-int((1+1)/2)))+((0*0*((1-1)/2+1-0))*(int((1+1)/2)-int(1/2))+(0*0*(int(1/2)+1-0-0))*(int((1+2)/2)-int((1+1)/2))))/1 \
        pd=(((4.8e-07+((1-1)*5.4e-07)/2+0)*(int((1+1)/2)-int(1/2))+(1/2)*5.4e-07*(int((1+2)/2)-int((1+1)/2)))*2+(((1+1)*(int((1+1)/2)-int(1/2))+(1+0)*(int((1+2)/2)-int((1+1)/2)))-((0*(((1+1)*(int((1+1)/2)-int(1/2))+(1+0)*(int((1+2)/2)-int((1+1)/2)))-0))*(int((1+1)/2)-int(1/2))+(0*((1+1)*(int((1+1)/2)-int(1/2))+(1+0)*(int((1+2)/2)-int((1+1)/2))))*(int((1+2)/2)-int((1+1)/2))))*WK1+((0*((1-1)/2+1-0))*(int((1+1)/2)-int(1/2))+(0*int(1/2))*(int((1+2)/2)-int((1+1)/2)))*4)/1 \
        ps=(((4.8e-07+((1-1)*5.4e-07)/2+0)*(int((1+1)/2)-int(1/2))+(4.8e-07+4.8e-07+(int(1/2)-1)*5.4e-07+0+0)*(int((1+2)/2)-int((1+1)/2)))*2+(((1+1)*(int((1+1)/2)-int(1/2))+(1+2)*(int((1+2)/2)-int((1+1)/2)))-((0*(((1+1)*(int((1+1)/2)-int(1/2))+(1+2)*(int((1+2)/2)-int((1+1)/2)))-0))*(int((1+1)/2)-int(1/2))+(0*(((1+1)*(int((1+1)/2)-int(1/2))+(1+2)*(int((1+2)/2)-int((1+1)/2)))-0-0))*(int((1+2)/2)-int((1+1)/2))))*WK1+((0*((1-1)/2+1-0))*(int((1+1)/2)-int(1/2))+(0*(int(1/2)+1-0-0))*(int((1+2)/2)-int((1+1)/2)))*4)/1 \
        nrd=(5.4e-07+2.7e-07*(1*2-2))/1/(WK1*2) \
        nrs=(5.4e-07+2.7e-07*(1*2-2))/1/(WK1*2)
    M124 (net41 CLKFIAB AGND AGND) nch_mis l=180.0n w=WK multi=(1) \
        ad=(WK*((4.8e-07+((1-1)*5.4e-07)/2+0)*(int((1+1)/2)-int(1/2))+(1/2)*5.4e-07*(int((1+2)/2)-int((1+1)/2)))+((0*0*((1-1)/2+1-0))*(int((1+1)/2)-int(1/2))+(0*0*int(1/2))*(int((1+2)/2)-int((1+1)/2))))/1 \
        as=(WK*((4.8e-07+((1-1)*5.4e-07)/2+0)*(int((1+1)/2)-int(1/2))+(4.8e-07+4.8e-07+(int(1/2)-1)*5.4e-07+0+0)*(int((1+2)/2)-int((1+1)/2)))+((0*0*((1-1)/2+1-0))*(int((1+1)/2)-int(1/2))+(0*0*(int(1/2)+1-0-0))*(int((1+2)/2)-int((1+1)/2))))/1 \
        pd=(((4.8e-07+((1-1)*5.4e-07)/2+0)*(int((1+1)/2)-int(1/2))+(1/2)*5.4e-07*(int((1+2)/2)-int((1+1)/2)))*2+(((1+1)*(int((1+1)/2)-int(1/2))+(1+0)*(int((1+2)/2)-int((1+1)/2)))-((0*(((1+1)*(int((1+1)/2)-int(1/2))+(1+0)*(int((1+2)/2)-int((1+1)/2)))-0))*(int((1+1)/2)-int(1/2))+(0*((1+1)*(int((1+1)/2)-int(1/2))+(1+0)*(int((1+2)/2)-int((1+1)/2))))*(int((1+2)/2)-int((1+1)/2))))*WK+((0*((1-1)/2+1-0))*(int((1+1)/2)-int(1/2))+(0*int(1/2))*(int((1+2)/2)-int((1+1)/2)))*4)/1 \
        ps=(((4.8e-07+((1-1)*5.4e-07)/2+0)*(int((1+1)/2)-int(1/2))+(4.8e-07+4.8e-07+(int(1/2)-1)*5.4e-07+0+0)*(int((1+2)/2)-int((1+1)/2)))*2+(((1+1)*(int((1+1)/2)-int(1/2))+(1+2)*(int((1+2)/2)-int((1+1)/2)))-((0*(((1+1)*(int((1+1)/2)-int(1/2))+(1+2)*(int((1+2)/2)-int((1+1)/2)))-0))*(int((1+1)/2)-int(1/2))+(0*(((1+1)*(int((1+1)/2)-int(1/2))+(1+2)*(int((1+2)/2)-int((1+1)/2)))-0-0))*(int((1+2)/2)-int((1+1)/2))))*WK+((0*((1-1)/2+1-0))*(int((1+1)/2)-int(1/2))+(0*(int(1/2)+1-0-0))*(int((1+2)/2)-int((1+1)/2)))*4)/1 \
        nrd=(5.4e-07+2.7e-07*(1*2-2))/1/(WK*2) \
        nrs=(5.4e-07+2.7e-07*(1*2-2))/1/(WK*2)
    M100 (net40 VIN V2 AGND) nch_mis l=180.0n w=2u multi=(1*F4) \
        ad=(2e-06*((4.8e-07+((F4-1)*5.4e-07)/2+0)*(int((F4+1)/2)-int(F4/2))+(F4/2)*5.4e-07*(int((F4+2)/2)-int((F4+1)/2)))+((0*0*((F4-1)/2+1-0))*(int((F4+1)/2)-int(F4/2))+(0*0*int(F4/2))*(int((F4+2)/2)-int((F4+1)/2))))/F4 \
        as=(2e-06*((4.8e-07+((F4-1)*5.4e-07)/2+0)*(int((F4+1)/2)-int(F4/2))+(4.8e-07+4.8e-07+(int(F4/2)-1)*5.4e-07+0+0)*(int((F4+2)/2)-int((F4+1)/2)))+((0*0*((F4-1)/2+1-0))*(int((F4+1)/2)-int(F4/2))+(0*0*(int(F4/2)+1-0-0))*(int((F4+2)/2)-int((F4+1)/2))))/F4 \
        pd=(((4.8e-07+((F4-1)*5.4e-07)/2+0)*(int((F4+1)/2)-int(F4/2))+(F4/2)*5.4e-07*(int((F4+2)/2)-int((F4+1)/2)))*2+(((F4+1)*(int((F4+1)/2)-int(F4/2))+(F4+0)*(int((F4+2)/2)-int((F4+1)/2)))-((0*(((F4+1)*(int((F4+1)/2)-int(F4/2))+(F4+0)*(int((F4+2)/2)-int((F4+1)/2)))-0))*(int((F4+1)/2)-int(F4/2))+(0*((F4+1)*(int((F4+1)/2)-int(F4/2))+(F4+0)*(int((F4+2)/2)-int((F4+1)/2))))*(int((F4+2)/2)-int((F4+1)/2))))*2e-06+((0*((F4-1)/2+1-0))*(int((F4+1)/2)-int(F4/2))+(0*int(F4/2))*(int((F4+2)/2)-int((F4+1)/2)))*4)/F4 \
        ps=(((4.8e-07+((F4-1)*5.4e-07)/2+0)*(int((F4+1)/2)-int(F4/2))+(4.8e-07+4.8e-07+(int(F4/2)-1)*5.4e-07+0+0)*(int((F4+2)/2)-int((F4+1)/2)))*2+(((F4+1)*(int((F4+1)/2)-int(F4/2))+(F4+2)*(int((F4+2)/2)-int((F4+1)/2)))-((0*(((F4+1)*(int((F4+1)/2)-int(F4/2))+(F4+2)*(int((F4+2)/2)-int((F4+1)/2)))-0))*(int((F4+1)/2)-int(F4/2))+(0*(((F4+1)*(int((F4+1)/2)-int(F4/2))+(F4+2)*(int((F4+2)/2)-int((F4+1)/2)))-0-0))*(int((F4+2)/2)-int((F4+1)/2))))*2e-06+((0*((F4-1)/2+1-0))*(int((F4+1)/2)-int(F4/2))+(0*(int(F4/2)+1-0-0))*(int((F4+2)/2)-int((F4+1)/2)))*4)/F4 \
        nrd=(5.4e-07+2.7e-07*(F4*2-2))/F4/(2e-06*2) \
        nrs=(5.4e-07+2.7e-07*(F4*2-2))/F4/(2e-06*2)
    M99 (net13605 VIP V2 AGND) nch_mis l=180.0n w=2u multi=(1*F4) \
        ad=(2e-06*((4.8e-07+((F4-1)*5.4e-07)/2+0)*(int((F4+1)/2)-int(F4/2))+(F4/2)*5.4e-07*(int((F4+2)/2)-int((F4+1)/2)))+((0*0*((F4-1)/2+1-0))*(int((F4+1)/2)-int(F4/2))+(0*0*int(F4/2))*(int((F4+2)/2)-int((F4+1)/2))))/F4 \
        as=(2e-06*((4.8e-07+((F4-1)*5.4e-07)/2+0)*(int((F4+1)/2)-int(F4/2))+(4.8e-07+4.8e-07+(int(F4/2)-1)*5.4e-07+0+0)*(int((F4+2)/2)-int((F4+1)/2)))+((0*0*((F4-1)/2+1-0))*(int((F4+1)/2)-int(F4/2))+(0*0*(int(F4/2)+1-0-0))*(int((F4+2)/2)-int((F4+1)/2))))/F4 \
        pd=(((4.8e-07+((F4-1)*5.4e-07)/2+0)*(int((F4+1)/2)-int(F4/2))+(F4/2)*5.4e-07*(int((F4+2)/2)-int((F4+1)/2)))*2+(((F4+1)*(int((F4+1)/2)-int(F4/2))+(F4+0)*(int((F4+2)/2)-int((F4+1)/2)))-((0*(((F4+1)*(int((F4+1)/2)-int(F4/2))+(F4+0)*(int((F4+2)/2)-int((F4+1)/2)))-0))*(int((F4+1)/2)-int(F4/2))+(0*((F4+1)*(int((F4+1)/2)-int(F4/2))+(F4+0)*(int((F4+2)/2)-int((F4+1)/2))))*(int((F4+2)/2)-int((F4+1)/2))))*2e-06+((0*((F4-1)/2+1-0))*(int((F4+1)/2)-int(F4/2))+(0*int(F4/2))*(int((F4+2)/2)-int((F4+1)/2)))*4)/F4 \
        ps=(((4.8e-07+((F4-1)*5.4e-07)/2+0)*(int((F4+1)/2)-int(F4/2))+(4.8e-07+4.8e-07+(int(F4/2)-1)*5.4e-07+0+0)*(int((F4+2)/2)-int((F4+1)/2)))*2+(((F4+1)*(int((F4+1)/2)-int(F4/2))+(F4+2)*(int((F4+2)/2)-int((F4+1)/2)))-((0*(((F4+1)*(int((F4+1)/2)-int(F4/2))+(F4+2)*(int((F4+2)/2)-int((F4+1)/2)))-0))*(int((F4+1)/2)-int(F4/2))+(0*(((F4+1)*(int((F4+1)/2)-int(F4/2))+(F4+2)*(int((F4+2)/2)-int((F4+1)/2)))-0-0))*(int((F4+2)/2)-int((F4+1)/2))))*2e-06+((0*((F4-1)/2+1-0))*(int((F4+1)/2)-int(F4/2))+(0*(int(F4/2)+1-0-0))*(int((F4+2)/2)-int((F4+1)/2)))*4)/F4 \
        nrd=(5.4e-07+2.7e-07*(F4*2-2))/F4/(2e-06*2) \
        nrs=(5.4e-07+2.7e-07*(F4*2-2))/F4/(2e-06*2)
    M98 (VON1 net39 V4 AGND) nch_mis l=180.0n*L w=1.5u multi=(1*F2*L) \
        ad=(1.5e-06*((4.8e-07+((F2*L-1)*5.4e-07)/2+0)*(int((F2*L+1)/2)-int(F2*L/2))+(F2*L/2)*5.4e-07*(int((F2*L+2)/2)-int((F2*L+1)/2)))+((0*0*((F2*L-1)/2+1-0))*(int((F2*L+1)/2)-int(F2*L/2))+(0*0*int(F2*L/2))*(int((F2*L+2)/2)-int((F2*L+1)/2))))/F2*L \
        as=(1.5e-06*((4.8e-07+((F2*L-1)*5.4e-07)/2+0)*(int((F2*L+1)/2)-int(F2*L/2))+(4.8e-07+4.8e-07+(int(F2*L/2)-1)*5.4e-07+0+0)*(int((F2*L+2)/2)-int((F2*L+1)/2)))+((0*0*((F2*L-1)/2+1-0))*(int((F2*L+1)/2)-int(F2*L/2))+(0*0*(int(F2*L/2)+1-0-0))*(int((F2*L+2)/2)-int((F2*L+1)/2))))/F2*L \
        pd=(((4.8e-07+((F2*L-1)*5.4e-07)/2+0)*(int((F2*L+1)/2)-int(F2*L/2))+(F2*L/2)*5.4e-07*(int((F2*L+2)/2)-int((F2*L+1)/2)))*2+(((F2*L+1)*(int((F2*L+1)/2)-int(F2*L/2))+(F2*L+0)*(int((F2*L+2)/2)-int((F2*L+1)/2)))-((0*(((F2*L+1)*(int((F2*L+1)/2)-int(F2*L/2))+(F2*L+0)*(int((F2*L+2)/2)-int((F2*L+1)/2)))-0))*(int((F2*L+1)/2)-int(F2*L/2))+(0*((F2*L+1)*(int((F2*L+1)/2)-int(F2*L/2))+(F2*L+0)*(int((F2*L+2)/2)-int((F2*L+1)/2))))*(int((F2*L+2)/2)-int((F2*L+1)/2))))*1.5e-06+((0*((F2*L-1)/2+1-0))*(int((F2*L+1)/2)-int(F2*L/2))+(0*int(F2*L/2))*(int((F2*L+2)/2)-int((F2*L+1)/2)))*4)/F2*L \
        ps=(((4.8e-07+((F2*L-1)*5.4e-07)/2+0)*(int((F2*L+1)/2)-int(F2*L/2))+(4.8e-07+4.8e-07+(int(F2*L/2)-1)*5.4e-07+0+0)*(int((F2*L+2)/2)-int((F2*L+1)/2)))*2+(((F2*L+1)*(int((F2*L+1)/2)-int(F2*L/2))+(F2*L+2)*(int((F2*L+2)/2)-int((F2*L+1)/2)))-((0*(((F2*L+1)*(int((F2*L+1)/2)-int(F2*L/2))+(F2*L+2)*(int((F2*L+2)/2)-int((F2*L+1)/2)))-0))*(int((F2*L+1)/2)-int(F2*L/2))+(0*(((F2*L+1)*(int((F2*L+1)/2)-int(F2*L/2))+(F2*L+2)*(int((F2*L+2)/2)-int((F2*L+1)/2)))-0-0))*(int((F2*L+2)/2)-int((F2*L+1)/2))))*1.5e-06+((0*((F2*L-1)/2+1-0))*(int((F2*L+1)/2)-int(F2*L/2))+(0*(int(F2*L/2)+1-0-0))*(int((F2*L+2)/2)-int((F2*L+1)/2)))*4)/F2*L \
        nrd=(5.4e-07+2.7e-07*(F2*L*2-2))/F2*L/(1.5e-06*2) \
        nrs=(5.4e-07+2.7e-07*(F2*L*2-2))/F2*L/(1.5e-06*2)
    M96 (VOP1 net38 V4 AGND) nch_mis l=180.0n*L w=1.5u multi=(1*F2*L) \
        ad=(1.5e-06*((4.8e-07+((F2*L-1)*5.4e-07)/2+0)*(int((F2*L+1)/2)-int(F2*L/2))+(F2*L/2)*5.4e-07*(int((F2*L+2)/2)-int((F2*L+1)/2)))+((0*0*((F2*L-1)/2+1-0))*(int((F2*L+1)/2)-int(F2*L/2))+(0*0*int(F2*L/2))*(int((F2*L+2)/2)-int((F2*L+1)/2))))/F2*L \
        as=(1.5e-06*((4.8e-07+((F2*L-1)*5.4e-07)/2+0)*(int((F2*L+1)/2)-int(F2*L/2))+(4.8e-07+4.8e-07+(int(F2*L/2)-1)*5.4e-07+0+0)*(int((F2*L+2)/2)-int((F2*L+1)/2)))+((0*0*((F2*L-1)/2+1-0))*(int((F2*L+1)/2)-int(F2*L/2))+(0*0*(int(F2*L/2)+1-0-0))*(int((F2*L+2)/2)-int((F2*L+1)/2))))/F2*L \
        pd=(((4.8e-07+((F2*L-1)*5.4e-07)/2+0)*(int((F2*L+1)/2)-int(F2*L/2))+(F2*L/2)*5.4e-07*(int((F2*L+2)/2)-int((F2*L+1)/2)))*2+(((F2*L+1)*(int((F2*L+1)/2)-int(F2*L/2))+(F2*L+0)*(int((F2*L+2)/2)-int((F2*L+1)/2)))-((0*(((F2*L+1)*(int((F2*L+1)/2)-int(F2*L/2))+(F2*L+0)*(int((F2*L+2)/2)-int((F2*L+1)/2)))-0))*(int((F2*L+1)/2)-int(F2*L/2))+(0*((F2*L+1)*(int((F2*L+1)/2)-int(F2*L/2))+(F2*L+0)*(int((F2*L+2)/2)-int((F2*L+1)/2))))*(int((F2*L+2)/2)-int((F2*L+1)/2))))*1.5e-06+((0*((F2*L-1)/2+1-0))*(int((F2*L+1)/2)-int(F2*L/2))+(0*int(F2*L/2))*(int((F2*L+2)/2)-int((F2*L+1)/2)))*4)/F2*L \
        ps=(((4.8e-07+((F2*L-1)*5.4e-07)/2+0)*(int((F2*L+1)/2)-int(F2*L/2))+(4.8e-07+4.8e-07+(int(F2*L/2)-1)*5.4e-07+0+0)*(int((F2*L+2)/2)-int((F2*L+1)/2)))*2+(((F2*L+1)*(int((F2*L+1)/2)-int(F2*L/2))+(F2*L+2)*(int((F2*L+2)/2)-int((F2*L+1)/2)))-((0*(((F2*L+1)*(int((F2*L+1)/2)-int(F2*L/2))+(F2*L+2)*(int((F2*L+2)/2)-int((F2*L+1)/2)))-0))*(int((F2*L+1)/2)-int(F2*L/2))+(0*(((F2*L+1)*(int((F2*L+1)/2)-int(F2*L/2))+(F2*L+2)*(int((F2*L+2)/2)-int((F2*L+1)/2)))-0-0))*(int((F2*L+2)/2)-int((F2*L+1)/2))))*1.5e-06+((0*((F2*L-1)/2+1-0))*(int((F2*L+1)/2)-int(F2*L/2))+(0*(int(F2*L/2)+1-0-0))*(int((F2*L+2)/2)-int((F2*L+1)/2)))*4)/F2*L \
        nrd=(5.4e-07+2.7e-07*(F2*L*2-2))/F2*L/(1.5e-06*2) \
        nrs=(5.4e-07+2.7e-07*(F2*L*2-2))/F2*L/(1.5e-06*2)
    M95 (V4 VB2 AGND AGND) nch_mis l=180.0n*L w=1.5u multi=(10) \
        ad=4.05e-13 as=4.68e-13 pd=2.04u ps=2.424u nrd=0.18 nrs=0.18
    I288 (net2 CLKFIA AVDD AGND) INVX3
    I231 (CLKAZ CLKAZB AVDD AGND) INVX3
    I235 (CLKFIA CLKFIAB AVDD AGND) INVX3
    I237 (CLK CLKB AVDD AGND) INVX3
    C13 (AVDD net46) mimcap l=10.36u w=10.36u m=1
    C12 (AVDD net45) mimcap l=10.36u w=10.36u m=1
    C11 (net44 net41) mimcap l=30u w=30u m=csup
    C10 (net39 AGND) mimcap l=10.36u w=10.36u m=1
    C9 (net38 AGND) mimcap l=10.36u w=10.36u m=1
    I148 (CLKB net14) not_gate vlogic_high=1.8 vlogic_low=0 vtrans=0.9 \
        tdel=tlatch trise=10p tfall=10p
    I245 (net14 CLKB1) not_gate vlogic_high=1.8 vlogic_low=0 vtrans=0.9 \
        tdel=10p trise=10p tfall=10p
    V0 (net1 AGND) vsource type=pulse val0=0 val1=vdd period=100n \
        delay=14.1n rise=10p fall=10p width=td-14n
    M166 (VON1 CLKAZ net46 AGND) nch l=180.0n w=WS m=1 \
        ad=(WS*((4.8e-07+((1-1)*5.4e-07)/2+0)*(int((1+1)/2)-int(1/2))+(1/2)*5.4e-07*(int((1+2)/2)-int((1+1)/2)))+((0*0*((1-1)/2+1-0))*(int((1+1)/2)-int(1/2))+(0*0*int(1/2))*(int((1+2)/2)-int((1+1)/2))))/1 \
        as=(WS*((4.8e-07+((1-1)*5.4e-07)/2+0)*(int((1+1)/2)-int(1/2))+(4.8e-07+4.8e-07+(int(1/2)-1)*5.4e-07+0+0)*(int((1+2)/2)-int((1+1)/2)))+((0*0*((1-1)/2+1-0))*(int((1+1)/2)-int(1/2))+(0*0*(int(1/2)+1-0-0))*(int((1+2)/2)-int((1+1)/2))))/1 \
        pd=(((4.8e-07+((1-1)*5.4e-07)/2+0)*(int((1+1)/2)-int(1/2))+(1/2)*5.4e-07*(int((1+2)/2)-int((1+1)/2)))*2+(((1+1)*(int((1+1)/2)-int(1/2))+(1+0)*(int((1+2)/2)-int((1+1)/2)))-((0*(((1+1)*(int((1+1)/2)-int(1/2))+(1+0)*(int((1+2)/2)-int((1+1)/2)))-0))*(int((1+1)/2)-int(1/2))+(0*((1+1)*(int((1+1)/2)-int(1/2))+(1+0)*(int((1+2)/2)-int((1+1)/2))))*(int((1+2)/2)-int((1+1)/2))))*WS+((0*((1-1)/2+1-0))*(int((1+1)/2)-int(1/2))+(0*int(1/2))*(int((1+2)/2)-int((1+1)/2)))*4)/1 \
        ps=(((4.8e-07+((1-1)*5.4e-07)/2+0)*(int((1+1)/2)-int(1/2))+(4.8e-07+4.8e-07+(int(1/2)-1)*5.4e-07+0+0)*(int((1+2)/2)-int((1+1)/2)))*2+(((1+1)*(int((1+1)/2)-int(1/2))+(1+2)*(int((1+2)/2)-int((1+1)/2)))-((0*(((1+1)*(int((1+1)/2)-int(1/2))+(1+2)*(int((1+2)/2)-int((1+1)/2)))-0))*(int((1+1)/2)-int(1/2))+(0*(((1+1)*(int((1+1)/2)-int(1/2))+(1+2)*(int((1+2)/2)-int((1+1)/2)))-0-0))*(int((1+2)/2)-int((1+1)/2))))*WS+((0*((1-1)/2+1-0))*(int((1+1)/2)-int(1/2))+(0*(int(1/2)+1-0-0))*(int((1+2)/2)-int((1+1)/2)))*4)/1 \
        nrd=(5.4e-07+2.7e-07*(1*2-2))/1/(WS*2) \
        nrs=(5.4e-07+2.7e-07*(1*2-2))/1/(WS*2)
    M165 (net45 CLKAZ VOP1 AGND) nch l=180.0n w=WS m=1 \
        ad=(WS*((4.8e-07+((1-1)*5.4e-07)/2+0)*(int((1+1)/2)-int(1/2))+(1/2)*5.4e-07*(int((1+2)/2)-int((1+1)/2)))+((0*0*((1-1)/2+1-0))*(int((1+1)/2)-int(1/2))+(0*0*int(1/2))*(int((1+2)/2)-int((1+1)/2))))/1 \
        as=(WS*((4.8e-07+((1-1)*5.4e-07)/2+0)*(int((1+1)/2)-int(1/2))+(4.8e-07+4.8e-07+(int(1/2)-1)*5.4e-07+0+0)*(int((1+2)/2)-int((1+1)/2)))+((0*0*((1-1)/2+1-0))*(int((1+1)/2)-int(1/2))+(0*0*(int(1/2)+1-0-0))*(int((1+2)/2)-int((1+1)/2))))/1 \
        pd=(((4.8e-07+((1-1)*5.4e-07)/2+0)*(int((1+1)/2)-int(1/2))+(1/2)*5.4e-07*(int((1+2)/2)-int((1+1)/2)))*2+(((1+1)*(int((1+1)/2)-int(1/2))+(1+0)*(int((1+2)/2)-int((1+1)/2)))-((0*(((1+1)*(int((1+1)/2)-int(1/2))+(1+0)*(int((1+2)/2)-int((1+1)/2)))-0))*(int((1+1)/2)-int(1/2))+(0*((1+1)*(int((1+1)/2)-int(1/2))+(1+0)*(int((1+2)/2)-int((1+1)/2))))*(int((1+2)/2)-int((1+1)/2))))*WS+((0*((1-1)/2+1-0))*(int((1+1)/2)-int(1/2))+(0*int(1/2))*(int((1+2)/2)-int((1+1)/2)))*4)/1 \
        ps=(((4.8e-07+((1-1)*5.4e-07)/2+0)*(int((1+1)/2)-int(1/2))+(4.8e-07+4.8e-07+(int(1/2)-1)*5.4e-07+0+0)*(int((1+2)/2)-int((1+1)/2)))*2+(((1+1)*(int((1+1)/2)-int(1/2))+(1+2)*(int((1+2)/2)-int((1+1)/2)))-((0*(((1+1)*(int((1+1)/2)-int(1/2))+(1+2)*(int((1+2)/2)-int((1+1)/2)))-0))*(int((1+1)/2)-int(1/2))+(0*(((1+1)*(int((1+1)/2)-int(1/2))+(1+2)*(int((1+2)/2)-int((1+1)/2)))-0-0))*(int((1+2)/2)-int((1+1)/2))))*WS+((0*((1-1)/2+1-0))*(int((1+1)/2)-int(1/2))+(0*(int(1/2)+1-0-0))*(int((1+2)/2)-int((1+1)/2)))*4)/1 \
        nrd=(5.4e-07+2.7e-07*(1*2-2))/1/(WS*2) \
        nrs=(5.4e-07+2.7e-07*(1*2-2))/1/(WS*2)
    M162 (net42 CLKFIAB VON1 AGND) nch l=180.0n w=WCM m=1 \
        ad=(WCM*((4.8e-07+((1-1)*5.4e-07)/2+0)*(int((1+1)/2)-int(1/2))+(1/2)*5.4e-07*(int((1+2)/2)-int((1+1)/2)))+((0*0*((1-1)/2+1-0))*(int((1+1)/2)-int(1/2))+(0*0*int(1/2))*(int((1+2)/2)-int((1+1)/2))))/1 \
        as=(WCM*((4.8e-07+((1-1)*5.4e-07)/2+0)*(int((1+1)/2)-int(1/2))+(4.8e-07+4.8e-07+(int(1/2)-1)*5.4e-07+0+0)*(int((1+2)/2)-int((1+1)/2)))+((0*0*((1-1)/2+1-0))*(int((1+1)/2)-int(1/2))+(0*0*(int(1/2)+1-0-0))*(int((1+2)/2)-int((1+1)/2))))/1 \
        pd=(((4.8e-07+((1-1)*5.4e-07)/2+0)*(int((1+1)/2)-int(1/2))+(1/2)*5.4e-07*(int((1+2)/2)-int((1+1)/2)))*2+(((1+1)*(int((1+1)/2)-int(1/2))+(1+0)*(int((1+2)/2)-int((1+1)/2)))-((0*(((1+1)*(int((1+1)/2)-int(1/2))+(1+0)*(int((1+2)/2)-int((1+1)/2)))-0))*(int((1+1)/2)-int(1/2))+(0*((1+1)*(int((1+1)/2)-int(1/2))+(1+0)*(int((1+2)/2)-int((1+1)/2))))*(int((1+2)/2)-int((1+1)/2))))*WCM+((0*((1-1)/2+1-0))*(int((1+1)/2)-int(1/2))+(0*int(1/2))*(int((1+2)/2)-int((1+1)/2)))*4)/1 \
        ps=(((4.8e-07+((1-1)*5.4e-07)/2+0)*(int((1+1)/2)-int(1/2))+(4.8e-07+4.8e-07+(int(1/2)-1)*5.4e-07+0+0)*(int((1+2)/2)-int((1+1)/2)))*2+(((1+1)*(int((1+1)/2)-int(1/2))+(1+2)*(int((1+2)/2)-int((1+1)/2)))-((0*(((1+1)*(int((1+1)/2)-int(1/2))+(1+2)*(int((1+2)/2)-int((1+1)/2)))-0))*(int((1+1)/2)-int(1/2))+(0*(((1+1)*(int((1+1)/2)-int(1/2))+(1+2)*(int((1+2)/2)-int((1+1)/2)))-0-0))*(int((1+2)/2)-int((1+1)/2))))*WCM+((0*((1-1)/2+1-0))*(int((1+1)/2)-int(1/2))+(0*(int(1/2)+1-0-0))*(int((1+2)/2)-int((1+1)/2)))*4)/1 \
        nrd=(5.4e-07+2.7e-07*(1*2-2))/1/(WCM*2) \
        nrs=(5.4e-07+2.7e-07*(1*2-2))/1/(WCM*2)
    M161 (VOP1 CLKFIAB net42 AGND) nch l=180.0n w=WCM m=1 \
        ad=(WCM*((4.8e-07+((1-1)*5.4e-07)/2+0)*(int((1+1)/2)-int(1/2))+(1/2)*5.4e-07*(int((1+2)/2)-int((1+1)/2)))+((0*0*((1-1)/2+1-0))*(int((1+1)/2)-int(1/2))+(0*0*int(1/2))*(int((1+2)/2)-int((1+1)/2))))/1 \
        as=(WCM*((4.8e-07+((1-1)*5.4e-07)/2+0)*(int((1+1)/2)-int(1/2))+(4.8e-07+4.8e-07+(int(1/2)-1)*5.4e-07+0+0)*(int((1+2)/2)-int((1+1)/2)))+((0*0*((1-1)/2+1-0))*(int((1+1)/2)-int(1/2))+(0*0*(int(1/2)+1-0-0))*(int((1+2)/2)-int((1+1)/2))))/1 \
        pd=(((4.8e-07+((1-1)*5.4e-07)/2+0)*(int((1+1)/2)-int(1/2))+(1/2)*5.4e-07*(int((1+2)/2)-int((1+1)/2)))*2+(((1+1)*(int((1+1)/2)-int(1/2))+(1+0)*(int((1+2)/2)-int((1+1)/2)))-((0*(((1+1)*(int((1+1)/2)-int(1/2))+(1+0)*(int((1+2)/2)-int((1+1)/2)))-0))*(int((1+1)/2)-int(1/2))+(0*((1+1)*(int((1+1)/2)-int(1/2))+(1+0)*(int((1+2)/2)-int((1+1)/2))))*(int((1+2)/2)-int((1+1)/2))))*WCM+((0*((1-1)/2+1-0))*(int((1+1)/2)-int(1/2))+(0*int(1/2))*(int((1+2)/2)-int((1+1)/2)))*4)/1 \
        ps=(((4.8e-07+((1-1)*5.4e-07)/2+0)*(int((1+1)/2)-int(1/2))+(4.8e-07+4.8e-07+(int(1/2)-1)*5.4e-07+0+0)*(int((1+2)/2)-int((1+1)/2)))*2+(((1+1)*(int((1+1)/2)-int(1/2))+(1+2)*(int((1+2)/2)-int((1+1)/2)))-((0*(((1+1)*(int((1+1)/2)-int(1/2))+(1+2)*(int((1+2)/2)-int((1+1)/2)))-0))*(int((1+1)/2)-int(1/2))+(0*(((1+1)*(int((1+1)/2)-int(1/2))+(1+2)*(int((1+2)/2)-int((1+1)/2)))-0-0))*(int((1+2)/2)-int((1+1)/2))))*WCM+((0*((1-1)/2+1-0))*(int((1+1)/2)-int(1/2))+(0*(int(1/2)+1-0-0))*(int((1+2)/2)-int((1+1)/2)))*4)/1 \
        nrd=(5.4e-07+2.7e-07*(1*2-2))/1/(WCM*2) \
        nrs=(5.4e-07+2.7e-07*(1*2-2))/1/(WCM*2)
    M156 (net38 CLKAZ VOP1 AGND) nch l=180.0n w=WS m=1 \
        ad=(WS*((4.8e-07+((1-1)*5.4e-07)/2+0)*(int((1+1)/2)-int(1/2))+(1/2)*5.4e-07*(int((1+2)/2)-int((1+1)/2)))+((0*0*((1-1)/2+1-0))*(int((1+1)/2)-int(1/2))+(0*0*int(1/2))*(int((1+2)/2)-int((1+1)/2))))/1 \
        as=(WS*((4.8e-07+((1-1)*5.4e-07)/2+0)*(int((1+1)/2)-int(1/2))+(4.8e-07+4.8e-07+(int(1/2)-1)*5.4e-07+0+0)*(int((1+2)/2)-int((1+1)/2)))+((0*0*((1-1)/2+1-0))*(int((1+1)/2)-int(1/2))+(0*0*(int(1/2)+1-0-0))*(int((1+2)/2)-int((1+1)/2))))/1 \
        pd=(((4.8e-07+((1-1)*5.4e-07)/2+0)*(int((1+1)/2)-int(1/2))+(1/2)*5.4e-07*(int((1+2)/2)-int((1+1)/2)))*2+(((1+1)*(int((1+1)/2)-int(1/2))+(1+0)*(int((1+2)/2)-int((1+1)/2)))-((0*(((1+1)*(int((1+1)/2)-int(1/2))+(1+0)*(int((1+2)/2)-int((1+1)/2)))-0))*(int((1+1)/2)-int(1/2))+(0*((1+1)*(int((1+1)/2)-int(1/2))+(1+0)*(int((1+2)/2)-int((1+1)/2))))*(int((1+2)/2)-int((1+1)/2))))*WS+((0*((1-1)/2+1-0))*(int((1+1)/2)-int(1/2))+(0*int(1/2))*(int((1+2)/2)-int((1+1)/2)))*4)/1 \
        ps=(((4.8e-07+((1-1)*5.4e-07)/2+0)*(int((1+1)/2)-int(1/2))+(4.8e-07+4.8e-07+(int(1/2)-1)*5.4e-07+0+0)*(int((1+2)/2)-int((1+1)/2)))*2+(((1+1)*(int((1+1)/2)-int(1/2))+(1+2)*(int((1+2)/2)-int((1+1)/2)))-((0*(((1+1)*(int((1+1)/2)-int(1/2))+(1+2)*(int((1+2)/2)-int((1+1)/2)))-0))*(int((1+1)/2)-int(1/2))+(0*(((1+1)*(int((1+1)/2)-int(1/2))+(1+2)*(int((1+2)/2)-int((1+1)/2)))-0-0))*(int((1+2)/2)-int((1+1)/2))))*WS+((0*((1-1)/2+1-0))*(int((1+1)/2)-int(1/2))+(0*(int(1/2)+1-0-0))*(int((1+2)/2)-int((1+1)/2)))*4)/1 \
        nrd=(5.4e-07+2.7e-07*(1*2-2))/1/(WS*2) \
        nrs=(5.4e-07+2.7e-07*(1*2-2))/1/(WS*2)
    M155 (VON1 CLKAZ net39 AGND) nch l=180.0n w=WS m=1 \
        ad=(WS*((4.8e-07+((1-1)*5.4e-07)/2+0)*(int((1+1)/2)-int(1/2))+(1/2)*5.4e-07*(int((1+2)/2)-int((1+1)/2)))+((0*0*((1-1)/2+1-0))*(int((1+1)/2)-int(1/2))+(0*0*int(1/2))*(int((1+2)/2)-int((1+1)/2))))/1 \
        as=(WS*((4.8e-07+((1-1)*5.4e-07)/2+0)*(int((1+1)/2)-int(1/2))+(4.8e-07+4.8e-07+(int(1/2)-1)*5.4e-07+0+0)*(int((1+2)/2)-int((1+1)/2)))+((0*0*((1-1)/2+1-0))*(int((1+1)/2)-int(1/2))+(0*0*(int(1/2)+1-0-0))*(int((1+2)/2)-int((1+1)/2))))/1 \
        pd=(((4.8e-07+((1-1)*5.4e-07)/2+0)*(int((1+1)/2)-int(1/2))+(1/2)*5.4e-07*(int((1+2)/2)-int((1+1)/2)))*2+(((1+1)*(int((1+1)/2)-int(1/2))+(1+0)*(int((1+2)/2)-int((1+1)/2)))-((0*(((1+1)*(int((1+1)/2)-int(1/2))+(1+0)*(int((1+2)/2)-int((1+1)/2)))-0))*(int((1+1)/2)-int(1/2))+(0*((1+1)*(int((1+1)/2)-int(1/2))+(1+0)*(int((1+2)/2)-int((1+1)/2))))*(int((1+2)/2)-int((1+1)/2))))*WS+((0*((1-1)/2+1-0))*(int((1+1)/2)-int(1/2))+(0*int(1/2))*(int((1+2)/2)-int((1+1)/2)))*4)/1 \
        ps=(((4.8e-07+((1-1)*5.4e-07)/2+0)*(int((1+1)/2)-int(1/2))+(4.8e-07+4.8e-07+(int(1/2)-1)*5.4e-07+0+0)*(int((1+2)/2)-int((1+1)/2)))*2+(((1+1)*(int((1+1)/2)-int(1/2))+(1+2)*(int((1+2)/2)-int((1+1)/2)))-((0*(((1+1)*(int((1+1)/2)-int(1/2))+(1+2)*(int((1+2)/2)-int((1+1)/2)))-0))*(int((1+1)/2)-int(1/2))+(0*(((1+1)*(int((1+1)/2)-int(1/2))+(1+2)*(int((1+2)/2)-int((1+1)/2)))-0-0))*(int((1+2)/2)-int((1+1)/2))))*WS+((0*((1-1)/2+1-0))*(int((1+1)/2)-int(1/2))+(0*(int(1/2)+1-0-0))*(int((1+2)/2)-int((1+1)/2)))*4)/1 \
        nrd=(5.4e-07+2.7e-07*(1*2-2))/1/(WS*2) \
        nrs=(5.4e-07+2.7e-07*(1*2-2))/1/(WS*2)
    M77 (VB2 VB2 AGND AGND) nch l=180.0n w=1u m=1 ad=4.8e-13 as=4.8e-13 \
        pd=2.96u ps=2.96u nrd=0.27 nrs=0.27
    M76 (VB1 VB2 AGND AGND) nch l=180.0n w=2u m=1 ad=9.6e-13 as=9.6e-13 \
        pd=4.96u ps=4.96u nrd=0.135 nrs=0.135
    M72 (DN DP AGND AGND) nch l=180.0n w=220.0n m=1 ad=1.984e-13 \
        as=1.984e-13 pd=1.88u ps=1.88u nrd=1.40909 nrs=1.40909
    M71 (DP DN AGND AGND) nch l=180.0n w=220.0n m=1 ad=1.984e-13 \
        as=1.984e-13 pd=1.88u ps=1.88u nrd=1.40909 nrs=1.40909
    M70 (DN CLKB1 AGND AGND) nch l=180.0n w=220.0n m=1 ad=1.984e-13 \
        as=1.984e-13 pd=1.88u ps=1.88u nrd=1.40909 nrs=1.40909
    M69 (net13028 CLKB1 AGND AGND) nch l=180.0n w=220.0n m=1 ad=1.984e-13 \
        as=1.984e-13 pd=1.88u ps=1.88u nrd=1.40909 nrs=1.40909
    M68 (DP CLKB1 AGND AGND) nch l=180.0n w=220.0n m=1 ad=1.984e-13 \
        as=1.984e-13 pd=1.88u ps=1.88u nrd=1.40909 nrs=1.40909
    M67 (net13016 CLKB1 AGND AGND) nch l=180.0n w=220.0n m=1 ad=1.984e-13 \
        as=1.984e-13 pd=1.88u ps=1.88u nrd=1.40909 nrs=1.40909
    I223 (AVDD VB2) isource dc=2*IB type=dc
    I294 (RST net3 AVDD AGND) INVX1
    I229 (DP net5 AVDD AGND) INVX1
    I225 (DN net4 AVDD AGND) INVX1
    M164 (net46 CLKAZB VON1 AVDD) pch l=180.0n w=WS m=2 \
        ad=(WS*((4.8e-07+((2-1)*5.4e-07)/2+0)*(int((2+1)/2)-int(2/2))+(2/2)*5.4e-07*(int((2+2)/2)-int((2+1)/2)))+((0*0*((2-1)/2+1-0))*(int((2+1)/2)-int(2/2))+(0*0*int(2/2))*(int((2+2)/2)-int((2+1)/2))))/2 \
        as=(WS*((4.8e-07+((2-1)*5.4e-07)/2+0)*(int((2+1)/2)-int(2/2))+(4.8e-07+4.8e-07+(int(2/2)-1)*5.4e-07+0+0)*(int((2+2)/2)-int((2+1)/2)))+((0*0*((2-1)/2+1-0))*(int((2+1)/2)-int(2/2))+(0*0*(int(2/2)+1-0-0))*(int((2+2)/2)-int((2+1)/2))))/2 \
        pd=(((4.8e-07+((2-1)*5.4e-07)/2+0)*(int((2+1)/2)-int(2/2))+(2/2)*5.4e-07*(int((2+2)/2)-int((2+1)/2)))*2+(((2+1)*(int((2+1)/2)-int(2/2))+(2+0)*(int((2+2)/2)-int((2+1)/2)))-((0*(((2+1)*(int((2+1)/2)-int(2/2))+(2+0)*(int((2+2)/2)-int((2+1)/2)))-0))*(int((2+1)/2)-int(2/2))+(0*((2+1)*(int((2+1)/2)-int(2/2))+(2+0)*(int((2+2)/2)-int((2+1)/2))))*(int((2+2)/2)-int((2+1)/2))))*WS+((0*((2-1)/2+1-0))*(int((2+1)/2)-int(2/2))+(0*int(2/2))*(int((2+2)/2)-int((2+1)/2)))*4)/2 \
        ps=(((4.8e-07+((2-1)*5.4e-07)/2+0)*(int((2+1)/2)-int(2/2))+(4.8e-07+4.8e-07+(int(2/2)-1)*5.4e-07+0+0)*(int((2+2)/2)-int((2+1)/2)))*2+(((2+1)*(int((2+1)/2)-int(2/2))+(2+2)*(int((2+2)/2)-int((2+1)/2)))-((0*(((2+1)*(int((2+1)/2)-int(2/2))+(2+2)*(int((2+2)/2)-int((2+1)/2)))-0))*(int((2+1)/2)-int(2/2))+(0*(((2+1)*(int((2+1)/2)-int(2/2))+(2+2)*(int((2+2)/2)-int((2+1)/2)))-0-0))*(int((2+2)/2)-int((2+1)/2))))*WS+((0*((2-1)/2+1-0))*(int((2+1)/2)-int(2/2))+(0*(int(2/2)+1-0-0))*(int((2+2)/2)-int((2+1)/2)))*4)/2 \
        nrd=(5.4e-07+2.7e-07*(2*2-2))/2/(WS*2) \
        nrs=(5.4e-07+2.7e-07*(2*2-2))/2/(WS*2)
    M163 (VOP1 CLKAZB net45 AVDD) pch l=180.0n w=WS m=2 \
        ad=(WS*((4.8e-07+((2-1)*5.4e-07)/2+0)*(int((2+1)/2)-int(2/2))+(2/2)*5.4e-07*(int((2+2)/2)-int((2+1)/2)))+((0*0*((2-1)/2+1-0))*(int((2+1)/2)-int(2/2))+(0*0*int(2/2))*(int((2+2)/2)-int((2+1)/2))))/2 \
        as=(WS*((4.8e-07+((2-1)*5.4e-07)/2+0)*(int((2+1)/2)-int(2/2))+(4.8e-07+4.8e-07+(int(2/2)-1)*5.4e-07+0+0)*(int((2+2)/2)-int((2+1)/2)))+((0*0*((2-1)/2+1-0))*(int((2+1)/2)-int(2/2))+(0*0*(int(2/2)+1-0-0))*(int((2+2)/2)-int((2+1)/2))))/2 \
        pd=(((4.8e-07+((2-1)*5.4e-07)/2+0)*(int((2+1)/2)-int(2/2))+(2/2)*5.4e-07*(int((2+2)/2)-int((2+1)/2)))*2+(((2+1)*(int((2+1)/2)-int(2/2))+(2+0)*(int((2+2)/2)-int((2+1)/2)))-((0*(((2+1)*(int((2+1)/2)-int(2/2))+(2+0)*(int((2+2)/2)-int((2+1)/2)))-0))*(int((2+1)/2)-int(2/2))+(0*((2+1)*(int((2+1)/2)-int(2/2))+(2+0)*(int((2+2)/2)-int((2+1)/2))))*(int((2+2)/2)-int((2+1)/2))))*WS+((0*((2-1)/2+1-0))*(int((2+1)/2)-int(2/2))+(0*int(2/2))*(int((2+2)/2)-int((2+1)/2)))*4)/2 \
        ps=(((4.8e-07+((2-1)*5.4e-07)/2+0)*(int((2+1)/2)-int(2/2))+(4.8e-07+4.8e-07+(int(2/2)-1)*5.4e-07+0+0)*(int((2+2)/2)-int((2+1)/2)))*2+(((2+1)*(int((2+1)/2)-int(2/2))+(2+2)*(int((2+2)/2)-int((2+1)/2)))-((0*(((2+1)*(int((2+1)/2)-int(2/2))+(2+2)*(int((2+2)/2)-int((2+1)/2)))-0))*(int((2+1)/2)-int(2/2))+(0*(((2+1)*(int((2+1)/2)-int(2/2))+(2+2)*(int((2+2)/2)-int((2+1)/2)))-0-0))*(int((2+2)/2)-int((2+1)/2))))*WS+((0*((2-1)/2+1-0))*(int((2+1)/2)-int(2/2))+(0*(int(2/2)+1-0-0))*(int((2+2)/2)-int((2+1)/2)))*4)/2 \
        nrd=(5.4e-07+2.7e-07*(2*2-2))/2/(WS*2) \
        nrs=(5.4e-07+2.7e-07*(2*2-2))/2/(WS*2)
    M160 (net42 CLKFIA VOP1 AVDD) pch l=180.0n w=WCM m=2 \
        ad=(WCM*((4.8e-07+((2-1)*5.4e-07)/2+0)*(int((2+1)/2)-int(2/2))+(2/2)*5.4e-07*(int((2+2)/2)-int((2+1)/2)))+((0*0*((2-1)/2+1-0))*(int((2+1)/2)-int(2/2))+(0*0*int(2/2))*(int((2+2)/2)-int((2+1)/2))))/2 \
        as=(WCM*((4.8e-07+((2-1)*5.4e-07)/2+0)*(int((2+1)/2)-int(2/2))+(4.8e-07+4.8e-07+(int(2/2)-1)*5.4e-07+0+0)*(int((2+2)/2)-int((2+1)/2)))+((0*0*((2-1)/2+1-0))*(int((2+1)/2)-int(2/2))+(0*0*(int(2/2)+1-0-0))*(int((2+2)/2)-int((2+1)/2))))/2 \
        pd=(((4.8e-07+((2-1)*5.4e-07)/2+0)*(int((2+1)/2)-int(2/2))+(2/2)*5.4e-07*(int((2+2)/2)-int((2+1)/2)))*2+(((2+1)*(int((2+1)/2)-int(2/2))+(2+0)*(int((2+2)/2)-int((2+1)/2)))-((0*(((2+1)*(int((2+1)/2)-int(2/2))+(2+0)*(int((2+2)/2)-int((2+1)/2)))-0))*(int((2+1)/2)-int(2/2))+(0*((2+1)*(int((2+1)/2)-int(2/2))+(2+0)*(int((2+2)/2)-int((2+1)/2))))*(int((2+2)/2)-int((2+1)/2))))*WCM+((0*((2-1)/2+1-0))*(int((2+1)/2)-int(2/2))+(0*int(2/2))*(int((2+2)/2)-int((2+1)/2)))*4)/2 \
        ps=(((4.8e-07+((2-1)*5.4e-07)/2+0)*(int((2+1)/2)-int(2/2))+(4.8e-07+4.8e-07+(int(2/2)-1)*5.4e-07+0+0)*(int((2+2)/2)-int((2+1)/2)))*2+(((2+1)*(int((2+1)/2)-int(2/2))+(2+2)*(int((2+2)/2)-int((2+1)/2)))-((0*(((2+1)*(int((2+1)/2)-int(2/2))+(2+2)*(int((2+2)/2)-int((2+1)/2)))-0))*(int((2+1)/2)-int(2/2))+(0*(((2+1)*(int((2+1)/2)-int(2/2))+(2+2)*(int((2+2)/2)-int((2+1)/2)))-0-0))*(int((2+2)/2)-int((2+1)/2))))*WCM+((0*((2-1)/2+1-0))*(int((2+1)/2)-int(2/2))+(0*(int(2/2)+1-0-0))*(int((2+2)/2)-int((2+1)/2)))*4)/2 \
        nrd=(5.4e-07+2.7e-07*(2*2-2))/2/(WCM*2) \
        nrs=(5.4e-07+2.7e-07*(2*2-2))/2/(WCM*2)
    M159 (VON1 CLKFIA net42 AVDD) pch l=180.0n w=WCM m=2 \
        ad=(WCM*((4.8e-07+((2-1)*5.4e-07)/2+0)*(int((2+1)/2)-int(2/2))+(2/2)*5.4e-07*(int((2+2)/2)-int((2+1)/2)))+((0*0*((2-1)/2+1-0))*(int((2+1)/2)-int(2/2))+(0*0*int(2/2))*(int((2+2)/2)-int((2+1)/2))))/2 \
        as=(WCM*((4.8e-07+((2-1)*5.4e-07)/2+0)*(int((2+1)/2)-int(2/2))+(4.8e-07+4.8e-07+(int(2/2)-1)*5.4e-07+0+0)*(int((2+2)/2)-int((2+1)/2)))+((0*0*((2-1)/2+1-0))*(int((2+1)/2)-int(2/2))+(0*0*(int(2/2)+1-0-0))*(int((2+2)/2)-int((2+1)/2))))/2 \
        pd=(((4.8e-07+((2-1)*5.4e-07)/2+0)*(int((2+1)/2)-int(2/2))+(2/2)*5.4e-07*(int((2+2)/2)-int((2+1)/2)))*2+(((2+1)*(int((2+1)/2)-int(2/2))+(2+0)*(int((2+2)/2)-int((2+1)/2)))-((0*(((2+1)*(int((2+1)/2)-int(2/2))+(2+0)*(int((2+2)/2)-int((2+1)/2)))-0))*(int((2+1)/2)-int(2/2))+(0*((2+1)*(int((2+1)/2)-int(2/2))+(2+0)*(int((2+2)/2)-int((2+1)/2))))*(int((2+2)/2)-int((2+1)/2))))*WCM+((0*((2-1)/2+1-0))*(int((2+1)/2)-int(2/2))+(0*int(2/2))*(int((2+2)/2)-int((2+1)/2)))*4)/2 \
        ps=(((4.8e-07+((2-1)*5.4e-07)/2+0)*(int((2+1)/2)-int(2/2))+(4.8e-07+4.8e-07+(int(2/2)-1)*5.4e-07+0+0)*(int((2+2)/2)-int((2+1)/2)))*2+(((2+1)*(int((2+1)/2)-int(2/2))+(2+2)*(int((2+2)/2)-int((2+1)/2)))-((0*(((2+1)*(int((2+1)/2)-int(2/2))+(2+2)*(int((2+2)/2)-int((2+1)/2)))-0))*(int((2+1)/2)-int(2/2))+(0*(((2+1)*(int((2+1)/2)-int(2/2))+(2+2)*(int((2+2)/2)-int((2+1)/2)))-0-0))*(int((2+2)/2)-int((2+1)/2))))*WCM+((0*((2-1)/2+1-0))*(int((2+1)/2)-int(2/2))+(0*(int(2/2)+1-0-0))*(int((2+2)/2)-int((2+1)/2)))*4)/2 \
        nrd=(5.4e-07+2.7e-07*(2*2-2))/2/(WCM*2) \
        nrs=(5.4e-07+2.7e-07*(2*2-2))/2/(WCM*2)
    M158 (VOP1 CLKAZB net38 AVDD) pch l=180.0n w=WS m=2 \
        ad=(WS*((4.8e-07+((2-1)*5.4e-07)/2+0)*(int((2+1)/2)-int(2/2))+(2/2)*5.4e-07*(int((2+2)/2)-int((2+1)/2)))+((0*0*((2-1)/2+1-0))*(int((2+1)/2)-int(2/2))+(0*0*int(2/2))*(int((2+2)/2)-int((2+1)/2))))/2 \
        as=(WS*((4.8e-07+((2-1)*5.4e-07)/2+0)*(int((2+1)/2)-int(2/2))+(4.8e-07+4.8e-07+(int(2/2)-1)*5.4e-07+0+0)*(int((2+2)/2)-int((2+1)/2)))+((0*0*((2-1)/2+1-0))*(int((2+1)/2)-int(2/2))+(0*0*(int(2/2)+1-0-0))*(int((2+2)/2)-int((2+1)/2))))/2 \
        pd=(((4.8e-07+((2-1)*5.4e-07)/2+0)*(int((2+1)/2)-int(2/2))+(2/2)*5.4e-07*(int((2+2)/2)-int((2+1)/2)))*2+(((2+1)*(int((2+1)/2)-int(2/2))+(2+0)*(int((2+2)/2)-int((2+1)/2)))-((0*(((2+1)*(int((2+1)/2)-int(2/2))+(2+0)*(int((2+2)/2)-int((2+1)/2)))-0))*(int((2+1)/2)-int(2/2))+(0*((2+1)*(int((2+1)/2)-int(2/2))+(2+0)*(int((2+2)/2)-int((2+1)/2))))*(int((2+2)/2)-int((2+1)/2))))*WS+((0*((2-1)/2+1-0))*(int((2+1)/2)-int(2/2))+(0*int(2/2))*(int((2+2)/2)-int((2+1)/2)))*4)/2 \
        ps=(((4.8e-07+((2-1)*5.4e-07)/2+0)*(int((2+1)/2)-int(2/2))+(4.8e-07+4.8e-07+(int(2/2)-1)*5.4e-07+0+0)*(int((2+2)/2)-int((2+1)/2)))*2+(((2+1)*(int((2+1)/2)-int(2/2))+(2+2)*(int((2+2)/2)-int((2+1)/2)))-((0*(((2+1)*(int((2+1)/2)-int(2/2))+(2+2)*(int((2+2)/2)-int((2+1)/2)))-0))*(int((2+1)/2)-int(2/2))+(0*(((2+1)*(int((2+1)/2)-int(2/2))+(2+2)*(int((2+2)/2)-int((2+1)/2)))-0-0))*(int((2+2)/2)-int((2+1)/2))))*WS+((0*((2-1)/2+1-0))*(int((2+1)/2)-int(2/2))+(0*(int(2/2)+1-0-0))*(int((2+2)/2)-int((2+1)/2)))*4)/2 \
        nrd=(5.4e-07+2.7e-07*(2*2-2))/2/(WS*2) \
        nrs=(5.4e-07+2.7e-07*(2*2-2))/2/(WS*2)
    M157 (net39 CLKAZB VON1 AVDD) pch l=180.0n w=WS m=2 \
        ad=(WS*((4.8e-07+((2-1)*5.4e-07)/2+0)*(int((2+1)/2)-int(2/2))+(2/2)*5.4e-07*(int((2+2)/2)-int((2+1)/2)))+((0*0*((2-1)/2+1-0))*(int((2+1)/2)-int(2/2))+(0*0*int(2/2))*(int((2+2)/2)-int((2+1)/2))))/2 \
        as=(WS*((4.8e-07+((2-1)*5.4e-07)/2+0)*(int((2+1)/2)-int(2/2))+(4.8e-07+4.8e-07+(int(2/2)-1)*5.4e-07+0+0)*(int((2+2)/2)-int((2+1)/2)))+((0*0*((2-1)/2+1-0))*(int((2+1)/2)-int(2/2))+(0*0*(int(2/2)+1-0-0))*(int((2+2)/2)-int((2+1)/2))))/2 \
        pd=(((4.8e-07+((2-1)*5.4e-07)/2+0)*(int((2+1)/2)-int(2/2))+(2/2)*5.4e-07*(int((2+2)/2)-int((2+1)/2)))*2+(((2+1)*(int((2+1)/2)-int(2/2))+(2+0)*(int((2+2)/2)-int((2+1)/2)))-((0*(((2+1)*(int((2+1)/2)-int(2/2))+(2+0)*(int((2+2)/2)-int((2+1)/2)))-0))*(int((2+1)/2)-int(2/2))+(0*((2+1)*(int((2+1)/2)-int(2/2))+(2+0)*(int((2+2)/2)-int((2+1)/2))))*(int((2+2)/2)-int((2+1)/2))))*WS+((0*((2-1)/2+1-0))*(int((2+1)/2)-int(2/2))+(0*int(2/2))*(int((2+2)/2)-int((2+1)/2)))*4)/2 \
        ps=(((4.8e-07+((2-1)*5.4e-07)/2+0)*(int((2+1)/2)-int(2/2))+(4.8e-07+4.8e-07+(int(2/2)-1)*5.4e-07+0+0)*(int((2+2)/2)-int((2+1)/2)))*2+(((2+1)*(int((2+1)/2)-int(2/2))+(2+2)*(int((2+2)/2)-int((2+1)/2)))-((0*(((2+1)*(int((2+1)/2)-int(2/2))+(2+2)*(int((2+2)/2)-int((2+1)/2)))-0))*(int((2+1)/2)-int(2/2))+(0*(((2+1)*(int((2+1)/2)-int(2/2))+(2+2)*(int((2+2)/2)-int((2+1)/2)))-0-0))*(int((2+2)/2)-int((2+1)/2))))*WS+((0*((2-1)/2+1-0))*(int((2+1)/2)-int(2/2))+(0*(int(2/2)+1-0-0))*(int((2+2)/2)-int((2+1)/2)))*4)/2 \
        nrd=(5.4e-07+2.7e-07*(2*2-2))/2/(WS*2) \
        nrs=(5.4e-07+2.7e-07*(2*2-2))/2/(WS*2)
    M92 (VB1 VB1 AVDD AVDD) pch l=180.0n w=4u m=1 ad=1.92e-12 as=1.92e-12 \
        pd=8.96u ps=8.96u nrd=0.0675 nrs=0.0675
    M73 (DP DN net13016 AVDD) pch l=180.0n w=220.0n m=2 ad=1.102e-13 \
        as=1.984e-13 pd=1.04u ps=1.88u nrd=1.40909 nrs=1.40909
    M63 (DN DP net13028 AVDD) pch l=180.0n w=220.0n m=2 ad=1.102e-13 \
        as=1.984e-13 pd=1.04u ps=1.88u nrd=1.40909 nrs=1.40909
ends COM_IAZ

VSS (AGND 0) vsource dc=0 type=dc
VDD (AVDD AGND) vsource dc=vdd type=dc
VRST (RST AGND) vsource type=pulse val0=0 val1=vdd period=100n delay=100p rise=10p fall=10p width=18n
VCLK (CLK AGND) vsource type=pulse val0=0 val1=vdd period=10n delay=20n rise=10p fall=10p width=4n
VVIP (VIP AGND) vsource type=pwl wave=[0 0.9 19n 0.9 19.01n 0.91 59n 0.91 59.01n 0.89 119n 0.89 119.01n 0.91 159n 0.91]
VVIN (VIN AGND) vsource type=pwl wave=[0 0.9 19n 0.9 19.01n 0.89 59n 0.89 59.01n 0.91 119n 0.91 119.01n 0.89 159n 0.89]
XCOM (AGND AVDD CLK RST VIN VIP VON VOP) COM_IAZ
XMON (CLK RST VIN VIP VON VOP AGND AVDD) COM_MON
tran tran stop=160n maxstep=5p annotate=status
save CLK RST VIN VIP VON VOP XCOM.CLKAZ XCOM.CLKFIA XCOM.CLKB1
saveOptions options save=selected currents=selected
ahdl_include "/opt/cadence/IC618/tools/dfII/samples/artist/ahdlLib/not_gate/veriloga/veriloga.va"
ahdl_include "COM_MON.va"
