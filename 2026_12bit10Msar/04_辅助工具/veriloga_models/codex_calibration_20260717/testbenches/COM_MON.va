`include "constants.vams"
`include "disciplines.vams"

module COM_MON (CLK, RST, VIN, VIP, VON, VOP, AGND, AVDD);
    input CLK, RST, VIN, VIP, VON, VOP;
    inout AGND, AVDD;
    electrical CLK, RST, VIN, VIP, VON, VOP;
    electrical AGND, AVDD;

    integer sample_idx;
    integer rst_high;
    integer decision;
    real vth;

    analog begin
        vth = 0.5 * V(AVDD, AGND);
        @(initial_step) sample_idx = 0;

        @(cross(V(CLK, AGND) - vth, -1)) begin
            rst_high = (V(RST, AGND) > vth) ? 1 : 0;
            decision = (V(VOP, AGND) > V(VON, AGND)) ? 1 : 0;
            $strobe(
                "COM_MON sample=%0d t_ns=%0.3f rst=%0d vdiff_mv=%0.3f von=%0.6f vop=%0.6f decision=%0d",
                sample_idx, $abstime/1n, rst_high, 1e3*V(VIP, VIN),
                V(VON, AGND), V(VOP, AGND), decision);
            sample_idx = sample_idx + 1;
        end
    end
endmodule
