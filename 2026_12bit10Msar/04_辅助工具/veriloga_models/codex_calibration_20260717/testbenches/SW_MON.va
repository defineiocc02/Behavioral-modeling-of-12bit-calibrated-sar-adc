`include "constants.vams"
`include "disciplines.vams"

module SW_MON (MONCLK, BITD, BITU, AGND, AVDD);
    input MONCLK;
    input [1:13] BITD, BITU;
    inout AGND, AVDD;
    electrical MONCLK;
    electrical [1:13] BITD, BITU;
    electrical AGND, AVDD;

    integer sample_idx;
    integer dmask;
    integer umask;
    real vhigh;

    analog begin
        vhigh = 0.75 * V(AVDD, AGND);

        @(initial_step) sample_idx = 0;

        @(cross(V(MONCLK, AGND) - 0.5 * V(AVDD, AGND), -1)) begin
            dmask = 0;
            umask = 0;
            if (V(BITD[1],  AGND) > vhigh) dmask = dmask + 1;
            if (V(BITD[2],  AGND) > vhigh) dmask = dmask + 2;
            if (V(BITD[3],  AGND) > vhigh) dmask = dmask + 4;
            if (V(BITD[4],  AGND) > vhigh) dmask = dmask + 8;
            if (V(BITD[5],  AGND) > vhigh) dmask = dmask + 16;
            if (V(BITD[6],  AGND) > vhigh) dmask = dmask + 32;
            if (V(BITD[7],  AGND) > vhigh) dmask = dmask + 64;
            if (V(BITD[8],  AGND) > vhigh) dmask = dmask + 128;
            if (V(BITD[9],  AGND) > vhigh) dmask = dmask + 256;
            if (V(BITD[10], AGND) > vhigh) dmask = dmask + 512;
            if (V(BITD[11], AGND) > vhigh) dmask = dmask + 1024;
            if (V(BITD[12], AGND) > vhigh) dmask = dmask + 2048;
            if (V(BITD[13], AGND) > vhigh) dmask = dmask + 4096;

            if (V(BITU[1],  AGND) > vhigh) umask = umask + 1;
            if (V(BITU[2],  AGND) > vhigh) umask = umask + 2;
            if (V(BITU[3],  AGND) > vhigh) umask = umask + 4;
            if (V(BITU[4],  AGND) > vhigh) umask = umask + 8;
            if (V(BITU[5],  AGND) > vhigh) umask = umask + 16;
            if (V(BITU[6],  AGND) > vhigh) umask = umask + 32;
            if (V(BITU[7],  AGND) > vhigh) umask = umask + 64;
            if (V(BITU[8],  AGND) > vhigh) umask = umask + 128;
            if (V(BITU[9],  AGND) > vhigh) umask = umask + 256;
            if (V(BITU[10], AGND) > vhigh) umask = umask + 512;
            if (V(BITU[11], AGND) > vhigh) umask = umask + 1024;
            if (V(BITU[12], AGND) > vhigh) umask = umask + 2048;
            if (V(BITU[13], AGND) > vhigh) umask = umask + 4096;

            $strobe("SW_MON sample=%0d dmask=%0d umask=%0d", sample_idx, dmask, umask);
            sample_idx = sample_idx + 1;
        end
    end
endmodule
