`include "constants.vams"
`include "disciplines.vams"

module DEC_MON (SOUT, Bit, DGND, DVDD);
    input SOUT;
    input [11:0] Bit;
    inout DGND, DVDD;
    electrical SOUT;
    electrical [11:0] Bit;
    electrical DGND, DVDD;

    integer sample_idx;
    integer code;
    real vth;

    analog begin
        vth = 0.5 * V(DVDD, DGND);

        @(initial_step) begin
            sample_idx = 0;
            code = 0;
        end

        @(cross(V(SOUT, DGND) - vth, -1)) begin
            code = 0;
            if (V(Bit[0],  DGND) > vth) code = code + 1;
            if (V(Bit[1],  DGND) > vth) code = code + 2;
            if (V(Bit[2],  DGND) > vth) code = code + 4;
            if (V(Bit[3],  DGND) > vth) code = code + 8;
            if (V(Bit[4],  DGND) > vth) code = code + 16;
            if (V(Bit[5],  DGND) > vth) code = code + 32;
            if (V(Bit[6],  DGND) > vth) code = code + 64;
            if (V(Bit[7],  DGND) > vth) code = code + 128;
            if (V(Bit[8],  DGND) > vth) code = code + 256;
            if (V(Bit[9],  DGND) > vth) code = code + 512;
            if (V(Bit[10], DGND) > vth) code = code + 1024;
            if (V(Bit[11], DGND) > vth) code = code + 2048;
            $strobe("DEC_MON sample=%0d code=%0d", sample_idx, code);
            sample_idx = sample_idx + 1;
        end
    end
endmodule
