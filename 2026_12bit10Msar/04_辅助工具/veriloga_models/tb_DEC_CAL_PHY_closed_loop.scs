simulator lang=spectre
global 0

ahdl_include "DEC_CAL_PHY.va"
ahdl_include "SWITCH_CAL.va"
ahdl_include "CAL_CMP_TB.va"

// Set md8/mu8 away from 1.0 to prove that the measured weight follows the
// physical main-array capacitor rather than a hard-coded ACT_W parameter.
parameters vdd=1.8 cunit=4f md8=1.0 mu8=1.0

VAGND (AGND 0) vsource dc=0
VDGND (DGND 0) vsource dc=0
VAVDD (AVDD AGND) vsource dc=vdd
VDVDD (DVDD DGND) vsource dc=vdd
VVCM  (VCM AGND) vsource dc=vdd/2
VREFP (VREFP AGND) vsource dc=vdd
VREFN (VREFN AGND) vsource dc=0
VVIN  (VIN AGND) vsource dc=vdd/2
VVIP  (VIP AGND) vsource dc=vdd/2

// These timings are copied from the current top-level netlist.
VRST  (RST AGND) vsource type=pulse val0=0 val1=vdd period=100n \
    delay=100p rise=10p fall=10p width=14.05n
VRST1 (RST1 AGND) vsource type=pulse val0=0 val1=vdd period=100n \
    delay=100p rise=10p fall=10p width=14n
VSOUT (SOUT DGND) vsource type=pulse val0=0 val1=vdd period=100n \
    delay=98n rise=10p fall=10p width=2n
VCLK00 (CLK00 DGND) vsource type=pulse val0=0 val1=vdd period=100n \
    delay=20n rise=10p fall=10p width=79n
VCLKSAR (CLK_SAR DGND) vsource type=pulse val0=0 val1=vdd period=5n \
    delay=20n rise=10p fall=10p width=2n
VCALCLK (CAL_CLK DGND) vsource type=pulse val0=0 val1=vdd period=10n \
    delay=55n rise=10p fall=10p width=5n
VCALRST (CAL_RST DGND) vsource type=pulse val0=vdd val1=0 period=1m \
    delay=50n rise=10p fall=10p width=900u

// Raw SAR and normal SWITCH controls are inactive during foreground cal.
VBP12 (BP12 DGND) vsource dc=0
VBP11 (BP11 DGND) vsource dc=0
VBP10 (BP10 DGND) vsource dc=0
VBP9  (BP9  DGND) vsource dc=0
VBP8  (BP8  DGND) vsource dc=0
VBP7  (BP7  DGND) vsource dc=0
VBP6  (BP6  DGND) vsource dc=0
VBP5  (BP5  DGND) vsource dc=0
VBP4  (BP4  DGND) vsource dc=0
VBP3  (BP3  DGND) vsource dc=0
VBP2  (BP2  DGND) vsource dc=0
VBP1  (BP1  DGND) vsource dc=0
VBP0  (BP0  DGND) vsource dc=0
VBP13 (BP13 DGND) vsource dc=0

VSET12 (SET12 DGND) vsource dc=0
VSET11 (SET11 DGND) vsource dc=0
VSET10 (SET10 DGND) vsource dc=0
VSET9  (SET9  DGND) vsource dc=0
VSET8  (SET8  DGND) vsource dc=0
VSET7  (SET7  DGND) vsource dc=0
VSET6  (SET6  DGND) vsource dc=0
VSET5  (SET5  DGND) vsource dc=0
VSET4  (SET4  DGND) vsource dc=0
VSET3  (SET3  DGND) vsource dc=0
VSET2  (SET2  DGND) vsource dc=0
VSET1  (SET1  DGND) vsource dc=0
VSET0  (SET0  DGND) vsource dc=0

VBN0  (BN0  DGND) vsource dc=0
VBN1  (BN1  DGND) vsource dc=0
VBN2  (BN2  DGND) vsource dc=0
VBN3  (BN3  DGND) vsource dc=0
VBN4  (BN4  DGND) vsource dc=0
VBN5  (BN5  DGND) vsource dc=0
VBN6  (BN6  DGND) vsource dc=0
VBN7  (BN7  DGND) vsource dc=0
VBN8  (BN8  DGND) vsource dc=0
VBN9  (BN9  DGND) vsource dc=0
VBN10 (BN10 DGND) vsource dc=0
VBN11 (BN11 DGND) vsource dc=0
VBN12 (BN12 DGND) vsource dc=0

VBPX0  (BPX0  DGND) vsource dc=0
VBPX1  (BPX1  DGND) vsource dc=0
VBPX2  (BPX2  DGND) vsource dc=0
VBPX3  (BPX3  DGND) vsource dc=0
VBPX4  (BPX4  DGND) vsource dc=0
VBPX5  (BPX5  DGND) vsource dc=0
VBPX6  (BPX6  DGND) vsource dc=0
VBPX7  (BPX7  DGND) vsource dc=0
VBPX8  (BPX8  DGND) vsource dc=0
VBPX9  (BPX9  DGND) vsource dc=0
VBPX10 (BPX10 DGND) vsource dc=0
VBPX11 (BPX11 DGND) vsource dc=0
VBPX12 (BPX12 DGND) vsource dc=0

XDEC (B11 B10 B9 B8 B7 B6 B5 B4 B3 B2 B1 B0 \
    BP0 BP1 BP2 BP3 BP4 BP5 BP6 BP7 BP8 BP9 BP10 BP11 BP12 BP13 \
    DGND DVDD SOUT COMP COMN RST1 CAL_RST CLK_SAR CLK00 CLK \
    DC0 DC1 DC2 DC3 DC4 DC5 DC6 DC7 DC8 DC9 DC10 DC11 DC12 \
    UC0 UC1 UC2 UC3 UC4 UC5 UC6 UC7 UC8 UC9 UC10 UC11 UC12 \
    CAL DONE ERR CAL_CLK) DEC_CAL_PHY DEBUG=1 CMP_SWAP=0

XSW (AGND AVDD \
    D1 D2 D3 D4 D5 D6 D7 D8 D9 D10 D11 D12 D13 \
    BN0 BN1 BN2 BN3 BN4 BN5 BN6 BN7 BN8 BN9 BN10 BN11 BN12 \
    BPX0 BPX1 BPX2 BPX3 BPX4 BPX5 BPX6 BPX7 BPX8 BPX9 BPX10 BPX11 BPX12 \
    U1 U2 U3 U4 U5 U6 U7 U8 U9 U10 U11 U12 U13 \
    N P RST RST1 \
    SET0 SET1 SET2 SET3 SET4 SET5 SET6 SET7 SET8 SET9 SET10 SET11 SET12 \
    VCM VIN VIP VREFN VREFP \
    DC0 DC1 DC2 DC3 DC4 DC5 DC6 DC7 DC8 DC9 DC10 DC11 DC12 \
    UC0 UC1 UC2 UC3 UC4 UC5 UC6 UC7 UC8 UC9 UC10 UC11 UC12 \
    CAL CAL_CLK) SWITCH_CAL

XCMP (P N CLK RST COMP COMN DGND DVDD) CAL_CMP_TB

// Real split CDAC topology.  Capacitors 1..7 are behind the 1C bridge;
// capacitors 8..12 are connected directly to the comparator top plate.
CD1  (D1  PD) capacitor c=1*cunit
CD2  (D2  PD) capacitor c=2*cunit
CD3  (D3  PD) capacitor c=4*cunit
CD4  (D4  PD) capacitor c=6*cunit
CD5  (D5  PD) capacitor c=10*cunit
CD6  (D6  PD) capacitor c=16*cunit
CD7  (D7  PD) capacitor c=24*cunit
CDBR (PD  P)  capacitor c=1*cunit
CD8  (D8  P)  capacitor c=md8*cunit
CD9  (D9  P)  capacitor c=2*cunit
CD10 (D10 P)  capacitor c=4*cunit
CD11 (D11 P)  capacitor c=8*cunit
CD12 (D12 P)  capacitor c=16*cunit
CD13 (D13 P)  capacitor c=2*cunit

CU1  (U1  PU) capacitor c=1*cunit
CU2  (U2  PU) capacitor c=2*cunit
CU3  (U3  PU) capacitor c=4*cunit
CU4  (U4  PU) capacitor c=6*cunit
CU5  (U5  PU) capacitor c=10*cunit
CU6  (U6  PU) capacitor c=16*cunit
CU7  (U7  PU) capacitor c=24*cunit
CUBR (PU  N)  capacitor c=1*cunit
CU8  (U8  N)  capacitor c=mu8*cunit
CU9  (U9  N)  capacitor c=2*cunit
CU10 (U10 N)  capacitor c=4*cunit
CU11 (U11 N)  capacitor c=8*cunit
CU12 (U12 N)  capacitor c=16*cunit
CU13 (U13 N)  capacitor c=2*cunit

// Equal comparator/top-plate parasitics change gain but not the ideal weight
// ratios; unequal parasitic regression is added after the nominal loop passes.
CPP (P AGND) capacitor c=5f
CPN (N AGND) capacitor c=5f

// Five default targets x two directions x seven residue frames x 8 pairs.
tran tran stop=69u maxstep=500p method=gear2only
save CAL DONE ERR CLK CAL_CLK COMP COMN P N PD PU DC0 DC4 DC5 DC6 DC7 DC12 UC0 UC4 UC5 UC6 UC7 UC12
saveOptions options save=selected
