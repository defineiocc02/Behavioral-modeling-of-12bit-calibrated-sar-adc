// Complete-SAR foreground calibration and calibrated decoder for
// test_12bit50MSAR_AMS_final_0716.
//
// This version implements the TRUE Huang 2024 algorithm:
//   * Each weight measurement is a COMPLETE 7-bit + terminal SAR conversion,
//     not a sign-search + absolute-value greedy search.
//   * The calibration DAC (C1..C7) follows the normal SAR operation:
//     48 -> 32 -> 20 -> 12 -> 8 -> 4 -> 2 -> terminal(1).
//   * D+ and D- are complete digital codes (0..127), not constructed residuals.
//   * The terminal bit is a REAL comparator decision, not a forced +1.
//
// Absolute-value code implementation:
//   calDAC always uses +direction (10) in BOTH D+ and D- directions.
//   D+ direction: target=10(+W), wall=01(-W)  -> residual R = W_target - W_wall
//   D- direction: target=01(-W), wall=10(+W)  -> residual R = W_wall - W_target = -R
//
//   D+ = floor(R)  if R > 0, else 0
//   D- = floor(-R) if R < 0, else 0
//   D+ - D- = trunc(R)  [integer part of residual]
//
//   Weight = wall + (D+ - D-)  [NO division by 2]
//
//   This is mathematically equivalent to Huang's offset-code formula
//   W = wall + (D+_offset - D-_offset)/2, but uses absolute-value codes
//   instead of offset codes, avoiding the need for bidirectional SAR search.
//
// Physical mapping (unchanged from previous version):
//   stage 0 -> physical 13 = 16C (C12)
//   stage 1 -> physical 12 = 8C  (C11)
//   stage 2 -> physical 11 = 4C  (C10)
//   stage 3 -> physical 10 = 2C  (C9)
//   stage 4 -> physical 13 = 2C  (CR, redundant)
//   stage 5 -> physical 8  = 1C  (C8)
//   ...
//   stage 12 -> physical 1 = 1C  (C1)
//
// Calibration DAC = C1..C7 = stage 12..6 = BITD_CAL[12:6].
// Non-binary half-weights: 48, 32, 20, 12, 8, 4, 2.
// Terminal decision (weight 1) has no physical capacitor.
//
// SWITCH_CAL encoding (unchanged):
//   10 -> D/P side VREFP, U/N side VREFN  (+contribution)
//   01 -> D/P side VREFN, U/N side VREFP  (-contribution)
//   00 -> both VCM (inactive)
//
// Comparator decision (both directions, calDAC on d_mask):
//   P > N -> residual > 0 -> KEEP trial
//   P < N -> residual < 0 -> DROP trial
//
// Complete code:
//   D = 48*b7 + 32*b6 + 20*b5 + 12*b4 + 8*b3 + 4*b2 + 2*b1 + b_T
//   Range: 0..127
//
// Recursive sequence: C10 -> C11 -> C12.
//   C10 wall = C9 + CR (stage 3 + stage 4)
//   C11 wall = C10 + C9 + CR (stage 2 + 3 + 4)
//   C12 wall = C11 + C10 + C9 + CR (stage 1 + 2 + 3 + 4)

`include "constants.vams"
`include "disciplines.vams"

module DEC_CAL_PHY (
    Bit, BP, DGND, DVDD, SOUT,
    COMP, COMN, RST1, CAL_RST,
    CLK_SAR, CLK00, CLK,
    BITD_CAL, BITU_CAL,
    CAL, DONE, ERR, CAL_CLK
);

    inout [11:0] Bit;
    inout [13:0] BP;
    inout DGND, DVDD, SOUT;
    inout COMP, COMN, RST1, CAL_RST;
    inout CLK_SAR, CLK00, CLK;
    inout [12:0] BITD_CAL, BITU_CAL;
    output CAL, DONE, ERR;
    inout CAL_CLK;

    electrical [11:0] Bit;
    electrical [13:0] BP;
    electrical DGND, DVDD, SOUT;
    electrical COMP, COMN, RST1, CAL_RST;
    electrical CLK_SAR, CLK00, CLK;
    electrical [12:0] BITD_CAL, BITU_CAL;
    electrical CAL, DONE, ERR;
    electrical CAL_CLK;

    parameter real VTH_FRACTION = 0.5 from (0.0:1.0);
    parameter real TD = 0 from [0.0:inf);
    parameter real TR = 20p from (0.0:inf);
    parameter real TF = 20p from (0.0:inf);
    parameter real TD_CAL = 200p from [0.0:inf);
    parameter real TD_CMP_CAL = 2n from [0.0:inf);
    parameter integer CMP_SWAP = 1 from [0:1];
    parameter real CMP_VALID_FRACTION = 0.2 from (0.0:1.0);
    parameter integer MAX_INVALID = 3 from [0:100];
    parameter integer ZERO_ON_INVALID = 1 from [0:1];
    parameter integer FIRST_INVERT = 0 from [0:1];
    parameter integer RAW_INVERT = 0 from [0:1];
    parameter real WEIGHT_TOL = 0.25 from (0.0:1.0);
    parameter integer DEBUG = 1 from [0:1];

    // Q-format fractional bits for weight storage.
    parameter integer FRAC_BITS = 6 from [0:8];
    parameter integer AVG_PAIRS_LOG2 = 0 from [0:8];
    parameter integer AVG_LOG2 = 3 from [0:8];

    parameter integer CAL_C7 = 0 from [0:1];
    parameter integer CAL_BYPASS = 0 from [0:1];
    parameter integer NORMALIZE_REDUNDANT_RANGE = 1 from [0:1];
    parameter integer REMOVE_REDUNDANCY_OFFSET = 1 from [0:1];

    // Deprecated parameters kept for netlist compatibility.
    parameter real UPDATE_DEADBAND_LSB = 0.0 from [0.0:inf);
    parameter real HIGH_WEIGHT_UPDATE_DEADBAND_LSB = 0.0 from [0.0:inf);
    parameter integer APPLY_BIN_MIDPOINT = 0 from [0:1];
    parameter integer AUTO_BIN_MIDPOINT = 0 from [0:1];
    parameter integer ZERO_ON_INVALID_PHASE0 = 1 from [0:1];
    parameter integer ZERO_ON_INVALID_PHASE1 = 1 from [0:1];

    // Calibration state machine.
    //   CAL_IDLE:       waiting for CAL_RST
    //   CAL_PRECHARGE:  first CAL_CLK falling edge, set up target+wall
    //   CAL_SAR_TRIAL:  SAR successive approximation, steps 0..6
    //   CAL_TERMINAL:   final comparator decision (b_T)
    //   CAL_FINISH_DIR: one direction done, switch or compute
    integer cal_state;
    localparam CAL_IDLE       = 0;
    localparam CAL_PRECHARGE  = 1;
    localparam CAL_SAR_TRIAL  = 2;
    localparam CAL_TERMINAL   = 3;
    localparam CAL_FINISH_DIR = 4;

    integer sar_step;
    integer trial_mask;
    integer keep_mask;
    integer d_plus_code;
    integer d_minus_code;
    integer direction;          // 0: D+, 1: D-
    integer target_idx;         // 2=C10, 1=C11, 0=C12
    integer target_mask;
    integer wall_mask;
    integer d_mask;
    integer u_mask;

    integer repeat_idx;
    integer avg_pairs;
    integer accum_d_plus;
    integer accum_d_minus;
    integer q_scale;
    integer weight_frac_bits;

    integer cal_mode_i;
    integer cal_done_i;
    integer cal_error_i;
    integer cal_armed_i;
    integer cal_started_i;
    integer finish_pending_i;
    integer frame_active_i;
    integer invalid_count;
    integer zero_force_i;

    // Calibrated differential raw-decision weights in Q format.
    integer w0, w1, w2, w3, w4, w5, w6;
    integer w7, w8, w9, w10, w11, w12, w13;
    integer measured_weight_q;
    integer wall_weight_q;
    integer nominal_weight_q;
    integer candidate_weight_q;

    integer clk_sar_i;
    integer clk00_i;
    integer cal_clk_i;

    integer r0, r1, r2, r3, r4, r5, r6;
    integer r7, r8, r9, r10, r11, r12, r13;
    integer raw_sum;
    integer total_weight_q;
    integer redundancy_offset_q;
    integer centered_sum;
    integer adc_code;
    integer b0, b1, b2, b3, b4, b5;
    integer b6, b7, b8, b9, b10, b11;

    integer cmp_p_gt_n;
    integer cmp_valid;
    integer code_value;
    integer d_plus_avg;
    integer d_minus_avg;

    real vlogic;
    real vth;
    real cmp_delta;
    real cmp_valid_min;
    real scaled_code;

    genvar g;

    analog begin
        vlogic = V(DVDD, DGND);
        vth = VTH_FRACTION * vlogic;
        cmp_valid_min = CMP_VALID_FRACTION * vlogic;

        @(initial_step) begin
            weight_frac_bits = (FRAC_BITS < 6) ? 6 : FRAC_BITS;
            q_scale = 1 << weight_frac_bits;
            avg_pairs = 1 << AVG_PAIRS_LOG2;

            cal_state = CAL_IDLE;
            sar_step = 0;
            trial_mask = 0;
            keep_mask = 0;
            d_plus_code = 0;
            d_minus_code = 0;
            direction = 0;
            target_idx = 2;
            target_mask = 4;
            wall_mask = 24;
            d_mask = 0;
            u_mask = 0;
            repeat_idx = 0;
            accum_d_plus = 0;
            accum_d_minus = 0;

            cal_mode_i = 0;
            cal_done_i = 0;
            cal_error_i = 0;
            cal_armed_i = 0;
            cal_started_i = 0;
            finish_pending_i = 0;
            frame_active_i = 0;
            invalid_count = 0;
            zero_force_i = 0;

            w0 = 2048*q_scale;
            w1 = 1024*q_scale;
            w2 = 512*q_scale;
            w3 = 256*q_scale;
            w4 = 256*q_scale;
            w5 = 128*q_scale;
            w6 = 48*q_scale;
            w7 = 32*q_scale;
            w8 = 20*q_scale;
            w9 = 12*q_scale;
            w10 = 8*q_scale;
            w11 = 4*q_scale;
            w12 = 2*q_scale;
            w13 = q_scale;

            measured_weight_q = 0;
            wall_weight_q = 0;
            nominal_weight_q = 0;
            candidate_weight_q = 0;

            clk_sar_i = (V(CLK_SAR, DGND) > vth) ? 1 : 0;
            clk00_i = (V(CLK00, DGND) > vth) ? 1 : 0;
            cal_clk_i = (V(CAL_CLK, DGND) > vth) ? 1 : 0;

            adc_code = 0;

            if (CAL_BYPASS != 0) begin
                cal_mode_i = 0;
                cal_done_i = 1;
                cal_armed_i = 0;
            end else if (V(CAL_RST, DGND) < vth) begin
                cal_mode_i = 1;
                cal_armed_i = 1;
            end
        end

        // CAL_RST rising edge: reset state.
        @(cross(V(CAL_RST, DGND) - vth, +1)) begin
            weight_frac_bits = (FRAC_BITS < 6) ? 6 : FRAC_BITS;
            q_scale = 1 << weight_frac_bits;
            avg_pairs = 1 << AVG_PAIRS_LOG2;

            cal_state = CAL_IDLE;
            sar_step = 0;
            trial_mask = 0;
            keep_mask = 0;
            d_plus_code = 0;
            d_minus_code = 0;
            direction = 0;
            target_idx = 2;
            target_mask = 4;
            wall_mask = 24;
            d_mask = 0;
            u_mask = 0;
            repeat_idx = 0;
            accum_d_plus = 0;
            accum_d_minus = 0;

            cal_mode_i = 0;
            cal_done_i = (CAL_BYPASS != 0) ? 1 : 0;
            cal_error_i = 0;
            cal_armed_i = 0;
            cal_started_i = 0;
            finish_pending_i = 0;
            frame_active_i = 0;
            invalid_count = 0;
            zero_force_i = 0;

            w0 = 2048*q_scale;
            w1 = 1024*q_scale;
            w2 = 512*q_scale;
            w3 = 256*q_scale;
            w4 = 256*q_scale;
            w5 = 128*q_scale;
            w6 = 48*q_scale;
            w7 = 32*q_scale;
            w8 = 20*q_scale;
            w9 = 12*q_scale;
            w10 = 8*q_scale;
            w11 = 4*q_scale;
            w12 = 2*q_scale;
            w13 = q_scale;

            adc_code = 0;
        end

        // CAL_RST falling edge: start foreground calibration.
        @(cross(V(CAL_RST, DGND) - vth, -1)) begin
            if (CAL_BYPASS == 0) begin
                cal_state = CAL_IDLE;
                sar_step = 0;
                trial_mask = 0;
                keep_mask = 0;
                d_plus_code = 0;
                d_minus_code = 0;
                direction = 0;
                target_idx = 2;
                target_mask = 4;
                wall_mask = 24;
                d_mask = 0;
                u_mask = 0;
                repeat_idx = 0;
                accum_d_plus = 0;
                accum_d_minus = 0;

                cal_mode_i = 1;
                cal_done_i = 0;
                cal_error_i = 0;
                cal_armed_i = 1;
                cal_started_i = 0;
                finish_pending_i = 0;
                frame_active_i = 0;
                invalid_count = 0;
                zero_force_i = 0;

                if (DEBUG != 0)
                    $strobe("FULLSAR start t=%g", $abstime);
            end
        end

        // RST1 rising: end of frame, atomic CAL-to-normal handoff.
        @(cross(V(RST1, DGND) - vth, +1)) begin
            frame_active_i = 0;
            cal_started_i = 0;
            d_mask = 0;
            u_mask = 0;
            if ((cal_mode_i != 0) && (finish_pending_i != 0)) begin
                cal_mode_i = 0;
                cal_armed_i = 0;
                cal_started_i = 0;
                d_mask = 0;
                u_mask = 0;

                if (cal_error_i != 0) begin
                    w0 = 2048*q_scale;
                    w1 = 1024*q_scale;
                    w2 = 512*q_scale;
                    w3 = 256*q_scale;
                    w4 = 256*q_scale;
                    w5 = 128*q_scale;
                    w6 = 48*q_scale;
                    w7 = 32*q_scale;
                    w8 = 20*q_scale;
                    w9 = 12*q_scale;
                    w10 = 8*q_scale;
                    w11 = 4*q_scale;
                    w12 = 2*q_scale;
                    w13 = q_scale;
                end
                cal_done_i = 1;

                if (DEBUG != 0) begin
                    $strobe("FULLSAR finish t=%g done=%0d err=%0d",
                        $abstime, cal_done_i, cal_error_i);
                    $strobe("FULLSAR weights_q={%0d,%0d,%0d,%0d,%0d,%0d,%0d,%0d,%0d,%0d,%0d,%0d,%0d,%0d} Q=%0d",
                        w0, w1, w2, w3, w4, w5, w6, w7, w8,
                        w9, w10, w11, w12, w13, weight_frac_bits);
                end
            end
        end

        // RST1 falling: start of comparator evaluation interval.
        @(cross(V(RST1, DGND) - vth, -1)) begin
            if ((cal_mode_i != 0) && (finish_pending_i == 0)) begin
                frame_active_i = 1;
                cal_started_i = 0;
                d_mask = 0;
                u_mask = 0;
                cal_state = CAL_PRECHARGE;
                sar_step = 0;
                trial_mask = 0;
                keep_mask = 0;
                zero_force_i = 0;
                if (DEBUG != 0)
                    $strobe("FULLSAR frame start target=%0d dir=%0d pair=%0d t=%g",
                        target_idx, direction, repeat_idx, $abstime);
            end
        end

        // CAL_CLK rising: release top-plate VCM, apply trial.
        @(cross(V(CAL_CLK, DGND) - vth, +1)) begin
            if ((cal_mode_i != 0) && (frame_active_i != 0) &&
                (cal_started_i != 0) && (finish_pending_i == 0)) begin

                // Build d_mask/u_mask based on direction and state.
                // CRITICAL: calDAC always uses +direction (10) in BOTH D+ and D-.
                // D+ and D- differ only in target/wall encoding:
                //   D+: target=10(+W), wall=01(-W)  -> residual = +W_target - W_wall
                //   D-: target=01(-W), wall=10(+W)  -> residual = -W_target + W_wall
                // calDAC=10(+trial) in both directions.
                // This yields absolute-value codes:
                //   D+ = floor(R)  if R > 0, else 0
                //   D- = floor(-R) if R < 0, else 0
                // Weight = wall + (D+ - D-)  [NO division by 2]
                if (direction == 0) begin
                    // D+ direction: target=10(+), wall=01(-), calDAC=10(+)
                    d_mask = target_mask | keep_mask;
                    if (cal_state == CAL_SAR_TRIAL)
                        d_mask = d_mask | trial_mask;
                    u_mask = wall_mask;
                end else begin
                    // D- direction: target=01(-), wall=10(+), calDAC=10(+)
                    d_mask = wall_mask | keep_mask;
                    if (cal_state == CAL_SAR_TRIAL)
                        d_mask = d_mask | trial_mask;
                    u_mask = target_mask;
                end
            end
        end

        // CAL_CLK falling: capture comparator, advance SAR.
        @(cross(V(CAL_CLK, DGND) - vth, -1)) begin
            // First falling edge after RST1: establish precharge, no decision.
            if ((cal_mode_i != 0) && (frame_active_i != 0) &&
                (cal_started_i == 0) && (finish_pending_i == 0)) begin
                cal_started_i = 1;
                cal_state = CAL_SAR_TRIAL;
                sar_step = 0;
                trial_mask = 64;  // C7, stage 6, weight 48
                keep_mask = 0;

                // Precharge state: target+wall only, no trial yet.
                if (direction == 0) begin
                    d_mask = target_mask;
                    u_mask = wall_mask;
                end else begin
                    d_mask = wall_mask;
                    u_mask = target_mask;
                end
            end else if ((cal_mode_i != 0) && (frame_active_i != 0) &&
                (cal_started_i != 0) && (finish_pending_i == 0)) begin

                // Read comparator.
                cmp_delta = V(COMP, DGND) - V(COMN, DGND);
                if (cmp_delta < 0.0)
                    cmp_valid = ((-cmp_delta) > cmp_valid_min) ? 1 : 0;
                else
                    cmp_valid = (cmp_delta > cmp_valid_min) ? 1 : 0;

                if (cmp_valid == 0) begin
                    invalid_count = invalid_count + 1;
                    if (invalid_count > MAX_INVALID) begin
                        if (ZERO_ON_INVALID != 0) begin
                            // Near-zero residual: treat as exact hit.
                            // SAR step: keep trial (calDAC matches residual).
                            // Terminal step: b_T = 0 (exact match, no extra 1 LSB).
                            // This distinction is CRITICAL for even residuals:
                            //   R=+8 -> calDAC=8, terminal residual=0, b_T=0, D+=8 (correct)
                            //   If b_T=1 (old bug): D+=9 (+1 LSB error)
                            invalid_count = 0;
                            cmp_valid = 1;
                            if (cal_state == CAL_TERMINAL)
                                cmp_p_gt_n = 0;  // Terminal: exact match
                            else
                                cmp_p_gt_n = 1;  // SAR step: keep trial
                            // Skip comparator re-read: ZERO_ON_INVALID has set cmp_p_gt_n.
                            // Jump directly to decision logic by setting a flag.
                            zero_force_i = 1;
                            if (DEBUG != 0)
                                $strobe("FULLSAR zero-hit target=%0d dir=%0d step=%0d state=%0d t=%g",
                                    target_idx, direction, sar_step, cal_state, $abstime);
                        end else begin
                            cal_error_i = 1;
                            finish_pending_i = 1;
                            if (DEBUG != 0)
                                $strobe("FULLSAR invalid cmp target=%0d dir=%0d t=%g",
                                    target_idx, direction, $abstime);
                        end
                    end
                end

                if (cmp_valid != 0) begin
                    invalid_count = 0;

                    // Comparator polarity:
                    // COMP < COMN means P > N (with CMP_SWAP=1 this is flipped).
                    // Only re-read if NOT a ZERO_ON_INVALID force.
                    if (zero_force_i == 0) begin
                        cmp_p_gt_n = (V(COMP, DGND) < V(COMN, DGND)) ? 1 : 0;
                        if (CMP_SWAP != 0)
                            cmp_p_gt_n = 1 - cmp_p_gt_n;
                    end
                    zero_force_i = 0;  // Clear flag.

                    // Decision: P > N -> residual > 0 -> KEEP trial.
                    // This is identical for both D+ and D- directions.
                    if (cmp_p_gt_n != 0)
                        keep_mask = keep_mask | trial_mask;

                    if (cal_state == CAL_SAR_TRIAL) begin
                        sar_step = sar_step + 1;
                        case (sar_step)
                            1: trial_mask = 128;   // C6, stage 7, weight 32
                            2: trial_mask = 256;   // C5, stage 8, weight 20
                            3: trial_mask = 512;   // C4, stage 9, weight 12
                            4: trial_mask = 1024;  // C3, stage 10, weight 8
                            5: trial_mask = 2048;  // C2, stage 11, weight 4
                            6: trial_mask = 4096;  // C1, stage 12, weight 2
                            default: begin
                                // All 7 physical bits done. Terminal step.
                                cal_state = CAL_TERMINAL;
                                trial_mask = 0;
                            end
                        endcase
                    end else if (cal_state == CAL_TERMINAL) begin
                        // Terminal bit = final comparator decision.
                        // b_T = cmp_p_gt_n (1 if P>N, 0 if P<N).

                        // Compute complete code: D = sum(kept weights) + b_T.
                        code_value = 0;
                        if ((keep_mask & 64)    != 0) code_value = code_value + 48;
                        if ((keep_mask & 128)   != 0) code_value = code_value + 32;
                        if ((keep_mask & 256)   != 0) code_value = code_value + 20;
                        if ((keep_mask & 512)   != 0) code_value = code_value + 12;
                        if ((keep_mask & 1024)  != 0) code_value = code_value + 8;
                        if ((keep_mask & 2048)  != 0) code_value = code_value + 4;
                        if ((keep_mask & 4096)  != 0) code_value = code_value + 2;
                        code_value = code_value + (cmp_p_gt_n != 0 ? 1 : 0);

                        if (DEBUG != 0)
                            $strobe("FULLSAR code target=%0d dir=%0d pair=%0d D=%0d keep=0x%0h bT=%0d t=%g",
                                target_idx, direction, repeat_idx,
                                code_value, keep_mask, cmp_p_gt_n, $abstime);

                        // Save code for current direction.
                        if (direction == 0) begin
                            d_plus_code = code_value;
                            // Switch to D- direction.
                            direction = 1;
                            cal_state = CAL_PRECHARGE;
                            sar_step = 0;
                            trial_mask = 0;
                            keep_mask = 0;
                            cal_started_i = 0;
                            frame_active_i = 0;
                            d_mask = 0;
                            u_mask = 0;
                        end else begin
                            d_minus_code = code_value;

                            // Accumulate for averaging.
                            accum_d_plus = accum_d_plus + d_plus_code;
                            accum_d_minus = accum_d_minus + d_minus_code;

                            if (DEBUG != 0)
                                $strobe("FULLSAR pair target=%0d pair=%0d D+=%0d D-=%0d accumD+=%0d accumD-=%0d",
                                    target_idx, repeat_idx,
                                    d_plus_code, d_minus_code,
                                    accum_d_plus, accum_d_minus);

                            if (repeat_idx < (avg_pairs - 1)) begin
                                // More pairs needed.
                                repeat_idx = repeat_idx + 1;
                                direction = 0;
                                cal_state = CAL_PRECHARGE;
                                sar_step = 0;
                                trial_mask = 0;
                                keep_mask = 0;
                                cal_started_i = 0;
                                frame_active_i = 0;
                                d_mask = 0;
                                u_mask = 0;
                            end else begin
                                // All pairs done. Compute weight.
                                // Absolute-value code formula:
                                //   D+ = floor(R)  if R > 0, else 0
                                //   D- = floor(-R) if R < 0, else 0
                                //   D+ - D- = trunc(R)  [integer part of R]
                                // Weight = wall + (D+ - D-)  [NO division by 2]
                                // In Q format:
                                //   W_q = wall_q + (D+_avg - D-_avg) * q_scale

                                // Compute wall weight in Q format.
                                case (target_idx)
                                    2: begin
                                        wall_weight_q = w3 + w4;
                                        nominal_weight_q = 512*q_scale;
                                    end
                                    1: begin
                                        wall_weight_q = w2 + w3 + w4;
                                        nominal_weight_q = 1024*q_scale;
                                    end
                                    default: begin
                                        wall_weight_q = w1 + w2 + w3 + w4;
                                        nominal_weight_q = 2048*q_scale;
                                    end
                                endcase

                                // Average D+ and D- over pairs.
                                d_plus_avg = accum_d_plus / avg_pairs;
                                d_minus_avg = accum_d_minus / avg_pairs;

                                // measured_weight_q = wall_q + (D+_avg - D-_avg) * q_scale
                                // NO division by 2 (absolute-value code, not offset code)
                                measured_weight_q = wall_weight_q +
                                    (d_plus_avg - d_minus_avg) * q_scale;

                                candidate_weight_q = measured_weight_q;

                                if (DEBUG != 0)
                                    $strobe("FULLSAR measure target=%0d wall=%0d D+avg=%0d D-avg=%0d measured=%0d (%g LSB) nominal=%0d",
                                        target_idx, wall_weight_q,
                                        d_plus_avg, d_minus_avg,
                                        measured_weight_q,
                                        1.0*measured_weight_q/q_scale,
                                        nominal_weight_q);

                                // Safety check: reject implausible weights.
                                if ((candidate_weight_q <
                                        nominal_weight_q * (1.0 - WEIGHT_TOL)) ||
                                    (candidate_weight_q >
                                        nominal_weight_q * (1.0 + WEIGHT_TOL))) begin
                                    cal_error_i = 1;
                                    finish_pending_i = 1;
                                    if (DEBUG != 0)
                                        $strobe("FULLSAR weight OOR target=%0d measured=%0d nominal=%0d",
                                            target_idx, measured_weight_q,
                                            nominal_weight_q);
                                end else begin
                                    // Apply measured weight directly.
                                    // NO deadband, NO midpoint, NO guard.
                                    case (target_idx)
                                        0: w0 = candidate_weight_q;
                                        1: w1 = candidate_weight_q;
                                        2: w2 = candidate_weight_q;
                                    endcase

                                    if (DEBUG != 0)
                                        $strobe("FULLSAR weight target=%0d measured_q=%0d value=%g LSB (direct, no guard)",
                                            target_idx, candidate_weight_q,
                                            1.0*candidate_weight_q/q_scale);

                                    // Advance to next target.
                                    if (target_idx == 0) begin
                                        finish_pending_i = 1;
                                    end else begin
                                        // C10 -> C11 -> C12.
                                        if (target_idx == 2) begin
                                            target_idx = 1;
                                            target_mask = 2;
                                            wall_mask = 28;  // C10+C9+CR
                                        end else if (target_idx == 1) begin
                                            target_idx = 0;
                                            target_mask = 1;
                                            wall_mask = 30;  // C11+C10+C9+CR
                                        end
                                        direction = 0;
                                        repeat_idx = 0;
                                        accum_d_plus = 0;
                                        accum_d_minus = 0;
                                        cal_state = CAL_PRECHARGE;
                                        sar_step = 0;
                                        trial_mask = 0;
                                        keep_mask = 0;
                                        cal_started_i = 0;
                                        frame_active_i = 0;
                                        d_mask = 0;
                                        u_mask = 0;
                                    end
                                end
                            end
                        end
                    end
                end

                // Prepare reference state for next CAL_CLK cycle.
                if ((finish_pending_i != 0) || (frame_active_i == 0)) begin
                    d_mask = 0;
                    u_mask = 0;
                end else if (cal_started_i != 0) begin
                    // calDAC always on d_mask (+direction) in both D+ and D-.
                    if (direction == 0) begin
                        d_mask = target_mask | keep_mask;
                        if (cal_state == CAL_SAR_TRIAL)
                            d_mask = d_mask | trial_mask;
                        u_mask = wall_mask;
                    end else begin
                        d_mask = wall_mask | keep_mask;
                        if (cal_state == CAL_SAR_TRIAL)
                            d_mask = d_mask | trial_mask;
                        u_mask = target_mask;
                    end
                end
            end
        end

        // SOUT rising: latch and decode a completed normal SAR conversion.
        // BP<13>=MSB, BP<0>=terminal. Reverse to match w0..w13 stage order.
        @(cross(V(SOUT, DGND) - vth, +1)) begin
            if ((cal_done_i != 0) && (cal_mode_i == 0)) begin

                r0  = (V(BP[13], DGND) > vth) ? 1 : 0;
                r1  = (V(BP[12], DGND) > vth) ? 1 : 0;
                r2  = (V(BP[11], DGND) > vth) ? 1 : 0;
                r3  = (V(BP[10], DGND) > vth) ? 1 : 0;
                r4  = (V(BP[9],  DGND) > vth) ? 1 : 0;
                r5  = (V(BP[8],  DGND) > vth) ? 1 : 0;
                r6  = (V(BP[7],  DGND) > vth) ? 1 : 0;
                r7  = (V(BP[6],  DGND) > vth) ? 1 : 0;
                r8  = (V(BP[5],  DGND) > vth) ? 1 : 0;
                r9  = (V(BP[4],  DGND) > vth) ? 1 : 0;
                r10 = (V(BP[3],  DGND) > vth) ? 1 : 0;
                r11 = (V(BP[2],  DGND) > vth) ? 1 : 0;
                r12 = (V(BP[1],  DGND) > vth) ? 1 : 0;
                r13 = (V(BP[0],  DGND) > vth) ? 1 : 0;

                if (RAW_INVERT != 0) begin
                    r1 = 1-r1;   r2 = 1-r2;   r3 = 1-r3;
                    r4 = 1-r4;   r5 = 1-r5;   r6 = 1-r6;
                    r7 = 1-r7;   r8 = 1-r8;   r9 = 1-r9;
                    r10 = 1-r10; r11 = 1-r11; r12 = 1-r12;
                    r13 = 1-r13;
                end
                if (FIRST_INVERT != 0)
                    r0 = 1-r0;

                raw_sum = r0*w0 + r1*w1 + r2*w2 + r3*w3 + r4*w4 +
                    r5*w5 + r6*w6 + r7*w7 + r8*w8 + r9*w9 +
                    r10*w10 + r11*w11 + r12*w12 + r13*w13;

                total_weight_q = w0 + w1 + w2 + w3 + w4 + w5 + w6 + w7 +
                    w8 + w9 + w10 + w11 + w12 + w13;

                if ((NORMALIZE_REDUNDANT_RANGE != 0) &&
                    (total_weight_q > 0)) begin
                    scaled_code = 4095.0 * raw_sum / total_weight_q;
                end else begin
                    if (REMOVE_REDUNDANCY_OFFSET != 0) begin
                        redundancy_offset_q = total_weight_q - 4095*q_scale;
                        if (redundancy_offset_q >= 0)
                            centered_sum = raw_sum -
                                (redundancy_offset_q + 1)/2;
                        else
                            centered_sum = raw_sum -
                                (redundancy_offset_q - 1)/2;
                    end else begin
                        centered_sum = raw_sum;
                    end
                    scaled_code = 1.0 * centered_sum / q_scale;
                end
                adc_code = $rtoi(scaled_code + 0.5);
                if (adc_code < 0)
                    adc_code = 0;
                else if (adc_code > 4095)
                    adc_code = 4095;
            end
        end

        // Clock tracking.
        @(cross(V(CLK_SAR, DGND) - vth, +1)) clk_sar_i = 1;
        @(cross(V(CLK_SAR, DGND) - vth, -1)) clk_sar_i = 0;
        @(cross(V(CLK00, DGND) - vth, +1)) clk00_i = 1;
        @(cross(V(CLK00, DGND) - vth, -1)) clk00_i = 0;
        @(cross(V(CAL_CLK, DGND) - vth, +1)) cal_clk_i = 1;
        @(cross(V(CAL_CLK, DGND) - vth, -1)) cal_clk_i = 0;

        // Output drivers.
        b0  = (adc_code      ) & 1;
        b1  = (adc_code >>  1) & 1;
        b2  = (adc_code >>  2) & 1;
        b3  = (adc_code >>  3) & 1;
        b4  = (adc_code >>  4) & 1;
        b5  = (adc_code >>  5) & 1;
        b6  = (adc_code >>  6) & 1;
        b7  = (adc_code >>  7) & 1;
        b8  = (adc_code >>  8) & 1;
        b9  = (adc_code >>  9) & 1;
        b10 = (adc_code >> 10) & 1;
        b11 = (adc_code >> 11) & 1;

        V(CAL,  DGND) <+ vlogic * transition(cal_mode_i,  TD, TR, TF);
        V(DONE, DGND) <+ vlogic * transition(cal_done_i,  TD, TR, TF);
        V(ERR,  DGND) <+ vlogic * transition(cal_error_i, TD, TR, TF);
        V(CLK, DGND) <+ vlogic * (
            (1 - cal_mode_i) * transition(clk_sar_i, TD, TR, TF) +
            cal_mode_i * transition(
                cal_clk_i * frame_active_i * cal_started_i *
                    (1 - finish_pending_i),
                TD_CMP_CAL, TR, TF));

        V(Bit[0],  DGND) <+ vlogic * transition(b0,  TD, TR, TF);
        V(Bit[1],  DGND) <+ vlogic * transition(b1,  TD, TR, TF);
        V(Bit[2],  DGND) <+ vlogic * transition(b2,  TD, TR, TF);
        V(Bit[3],  DGND) <+ vlogic * transition(b3,  TD, TR, TF);
        V(Bit[4],  DGND) <+ vlogic * transition(b4,  TD, TR, TF);
        V(Bit[5],  DGND) <+ vlogic * transition(b5,  TD, TR, TF);
        V(Bit[6],  DGND) <+ vlogic * transition(b6,  TD, TR, TF);
        V(Bit[7],  DGND) <+ vlogic * transition(b7,  TD, TR, TF);
        V(Bit[8],  DGND) <+ vlogic * transition(b8,  TD, TR, TF);
        V(Bit[9],  DGND) <+ vlogic * transition(b9,  TD, TR, TF);
        V(Bit[10], DGND) <+ vlogic * transition(b10, TD, TR, TF);
        V(Bit[11], DGND) <+ vlogic * transition(b11, TD, TR, TF);

        for (g = 0; g < 13; g = g + 1) begin
            V(BITD_CAL[g], DGND) <+ vlogic * transition(
                (d_mask >> g) & 1, TD_CAL, TR, TF);
            V(BITU_CAL[g], DGND) <+ vlogic * transition(
                (u_mask >> g) & 1, TD_CAL, TR, TF);
        end
    end
endmodule
