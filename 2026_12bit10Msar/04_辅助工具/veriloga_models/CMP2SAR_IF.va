`include "constants.vams"
`include "disciplines.vams"

// CMP2SAR_IF
// Comparator-to-SAR decision interface for the 12-bit SAR ADC project.
//
// Function:
//   Convert the dynamic comparator differential outputs COMP/COMN into a
//   protected single-ended low-active decision signal DEC_N for the original
//   SAR_LOGIC COMN input.
//
// Safety rule:
//   DEC_N stays high unless the comparator is inside the valid evaluate window
//   and COMP/COMN form the selected complementary decision state.
//
// Default polarity, pol_sel = 0:
//   COMP=1, COMN=0, cmp_valid=1 -> DEC_N=0
//
// Reverse polarity, pol_sel = 1:
//   COMN=1, COMP=0, cmp_valid=1 -> DEC_N=0
//
// Important integration note:
//   CLK is the COM_IAZ comparator evaluate clock. Do not connect this pin to
//   CCLK, which is the SAR_LOGIC sampling/progress clock.
module CMP2SAR_IF(COMP, COMN, CLK, RST, PRST, DGND, DVDD, DEC_N);

    input COMP, COMN;
    input CLK;
    input RST, PRST;
    inout DGND, DVDD;
    output DEC_N;

    electrical COMP, COMN;
    electrical CLK;
    electrical RST, PRST;
    electrical DGND, DVDD;
    electrical DEC_N;

    // Delay from CLK evaluate edge to the point where comparator outputs are
    // trusted. This is the main functional timing knob. Sweep it first:
    // 200 ps, 500 ps, 800 ps, 1 ns.
    parameter real td_valid = 5e-10;

    // Output propagation delay and transition shaping. These mainly prevent
    // ideal discontinuities and emulate a small output buffer delay:
    //
    //   low decision path ~= CLK rise + td_valid + td_out + tf
    //   high recovery path extra delay ~= td_out + tr
    //
    // Keep td_out/tr/tf small at first. If Spectre convergence is poor, try
    // tr=tf=50 ps before changing the functional timing.
    parameter real td_out   = 1e-11;
    parameter real tr       = 1e-11;
    parameter real tf       = 1e-11;

    // Comparator polarity selector:
    //   0: low event = COMP & ~COMN
    //   1: low event = COMN & ~COMP
    parameter integer pol_sel = 0;

    real vdd_now;
    real vth;
    real clk_dly_v;

    integer clk_bit;
    integer clk_dly_bit;
    integer rst_bit;
    integer prst_bit;
    integer cmp_valid;

    integer comp_bit;
    integer comn_bit;

    integer low_event;
    integer dec_bit;

    analog begin
        // Track the actual digital supply so the logic threshold follows DVDD.
        vdd_now = V(DVDD, DGND);
        vth = 0.5 * vdd_now;

        // Build a delayed version of the comparator evaluate clock.
        clk_dly_v = absdelay(V(CLK, DGND), td_valid);

        // Convert analog voltages to behavioral logic bits using DVDD/2.
        clk_bit     = (V(CLK, DGND)  > vth);
        clk_dly_bit = (clk_dly_v     > vth);
        rst_bit     = (V(RST, DGND)  > vth);
        prst_bit    = (V(PRST, DGND) > vth);

        comp_bit    = (V(COMP, DGND) > vth);
        comn_bit    = (V(COMN, DGND) > vth);

        // Valid only after CLK has been high for td_valid, and outside both
        // comparator reset and SAR pre-reset.
        cmp_valid = clk_bit && clk_dly_bit && (!rst_bit) && (!prst_bit);

        // Generate the selected low-active decision event. Invalid states
        // COMP/COMN=00 and COMP/COMN=11 are intentionally filtered.
        if (pol_sel == 0) begin
            low_event = cmp_valid && comp_bit && (!comn_bit);
        end else begin
            low_event = cmp_valid && comn_bit && (!comp_bit);
        end

        // DEC_N is a safe-high signal. It only goes low for a valid decision.
        if (low_event) begin
            dec_bit = 0;
        end else begin
            dec_bit = 1;
        end

        // Drive an electrical output for Spectre/ADE mixed-signal transient use.
        V(DEC_N, DGND) <+ transition(dec_bit ? vdd_now : 0.0, td_out, tr, tf);
    end

endmodule
