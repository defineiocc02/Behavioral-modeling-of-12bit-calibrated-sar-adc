// Clean V6 offset-binary foreground calibration and calibrated decoder for
// test_12bit50MSAR_AMS_final_0716.
//
// V6.3: Identifiability-fixed 3-target calibration with implicit gauge
//
// HISTORY:
//   V6:   3-target (w2, w1, w0), 7-bit calDAC, ±126 range.
//         Issue: E=e3+e4 propagates as -E into w2/w1/w0.
//   V6.1: 4-target (+ w3+w4 joint). E propagation reduced to 1/1/1x.
//   V6.2: + w2 re-correction + saturation flag.
//         DEFECT (user-identified): w2 re-correction is mathematically
//         invalid. Reciprocal measurement W34-W2 with digital wall =
//         measured w2 yields measured = 512 identically, so
//         (measured - 512) = 0 and the correction is a no-op.
//         W2 and W34 are not separately identifiable from each other.
//   V6.3: This version. Fixes V6.2 identifiability bug and all P0 issues.
//
// V6.3 DESIGN (see doc/PROOF_V6_3_IDENTIFIABILITY.md for full derivation):
//
// 1) IMPLICIT GAUGE CONSTRAINT:
//    W3+W4 := 512 (by layout matching, |e3+e4| < ~1%).
//    The algorithm does NOT attempt to measure W3+W4 separately.
//    w3 and w4 stay at their nominal value 256 for the entire calibration.
//    This is a *design constraint*, not a measured quantity.
//
// 2) 3-TARGET RECURSIVE CALIBRATION (W2, W1, W0):
//    NOTE: Earlier V6.3 comments claimed "w1/w0 exact under gauge".
//    Independent review (see PROOF_V6_3_IDENTIFIABILITY.md §4.3 更正版)
//    found a sign error in that derivation. The actual propagation is:
//
//    target 2: measure W2,    wall_digital = 512
//              R = W2 - W34_phys = e2 - E
//              w2 = 512 + (e2 - E)               [residual: -E]
//
//    target 1: measure W1,    wall_digital = w2 + 512 = 1024 + (e2 - E)
//              R = W1 - (W2 + W34_phys) = e1 - e2 - E
//              w1 = 1024 + e1 - 2E                [residual: -2E, NOT exact]
//
//    target 0: measure W0,    wall_digital = w1 + w2 + 512
//                                    = 2048 + e1 + e2 - 3E
//              R = W0 - (W1 + W2 + W34_phys) = e0 - e1 - e2 - E
//              w0 = 2048 + e0 - 4E                [residual: -4E, NOT exact]
//
//    Net result: E propagates as (-E, -2E, -4E) to (w2, w1, w0).
//    This matches V6 (no gauge) — V6.3 does NOT improve E propagation
//    over V6. The improvement vs V6.2 is only removing the no-op
//    w2 re-correction and fixing P0 bugs.
//
//    To eliminate E entirely requires: E=0 physically, or an independent
//    W34 measurement (proven non-identifiable in §1), or an extra linearly
//    independent calibration equation (hardware change).
//
// 3) WHAT V6.3 DOES NOT DO (and why):
//    - Does NOT eliminate E propagation: residual (-E, -2E, -4E) remains.
//    - Does NOT measure W3+W4: W2 and W34 are reciprocal, not separable.
//    - Does NOT calibrate W5 (128): proven not measurable with ±126 calDAC.
//    - Does NOT measure common-mode gain: all walls are differential.
//    - Does NOT separate e3 vs e4: only their sum E enters as gauge error.
//
// 4) P0/P1 BUG FIXES vs V6.2 (including V6.3 review P0-2/P1-1/P1-2/P1-4):
//    a) wall_weight_q initialized in initial_step (was only set on
//       CAL_RST falling edge, broken if CAL_RST starts low at t=0).
//    b) RST1-rising handler (P0-2): direction-finish runs FIRST and may
//       set finish_pending_i=1 on the last target; handoff is then run
//       by an INDEPENDENT if (not else-if) on the SAME RST1 edge, so
//       DONE no longer requires an extra RST1 frame.
//    c) REJECT now sets cal_degraded_i; if any target is rejected, ERR=1
//       at finish. Downstream targets still run with the nominal weight
//       (calibrated update is skipped for rejected targets only).
//       Normal decoder does NOT apply partial calibrated weights when
//       ERR=1 — it falls back to nominal weights (P1-4 safe fail policy).
//    d) saturate_flag (single-bit, whole-target reject) replaced by
//       per-pair saturate_count (P1-1). A pair is saturated if EITHER
//       D+ OR D- hits the calDAC endpoint; the per-pair OR is evaluated
//       at D- completion so each pair contributes at most 1 to the
//       counter (was 2 per pair, max 2*avg_pairs, before).
//       Saturated pairs are EXCLUDED from accum_d_plus/accum_d_minus
//       (P1-2); residual_q is computed over valid_pair_count only.
//       A target is rejected if saturate_count*100 > SAT_RATIO_PCT*avg_pairs
//       OR if valid_pair_count == 0 (all pairs saturated).
//    e) Dead parameters removed from the user-facing CDF set
//       (ZERO_ON_INVALID_PHASE1, *_DEADBAND_*, *_BIN_MIDPOINT*,
//        SINGLE_PAIR_*, AVG_LOG2, CAL_C7, NORMALIZE_REDUNDANT_RANGE,
//        REMOVE_REDUNDANCY_OFFSET).
//        Internal legacy variables kept as locals, never exposed.
//
// REQUIRED CLOCK TOPOLOGY:
//   SYNC_asnyc symbol terminal CLK -> net CLK_SAR
//   DEC_CAL_PHY output CLK         -> final comparator net CLK
//   COM_ideal CLK                  -> final comparator net CLK
// No other module may drive final net CLK.
//
// CORRECT Huang 2024 algorithm implementation:
//   * wall residual: R = W_target - W_wall
//   * offset-binary SAR: calDAC starts all-10 (+126), switches to 01
//   * trial COUNTER-DIRECTED to residual (SAR converges)
//   * D+ and D- are complete offset-binary codes (0..127)
//   * R = D+ - D-  (comparator offset cancels)
//   * Q-format averaging preserves sub-LSB info
//   * terminal bit is REAL comparator decision

`include "constants.vams"
`include "disciplines.vams"

module DEC_CAL_PHY (
    Bit, BP, DGND, DVDD, SOUT,
    COMP, COMN, RST1, CAL_RST,
    CLK_SAR, CLK00, CLK,
    BITD_CAL, BITU_CAL,
    CAL, DONE, ERR, CAL_CLK
);

    output [11:0] Bit;
    input  [0:13] BP;
    inout  DGND, DVDD;
    input  SOUT;
    input  COMP, COMN;
    input  RST1, CAL_RST;
    input  CLK_SAR, CLK00;
    input  CAL_CLK;
    output CLK;
    output [0:12] BITD_CAL, BITU_CAL;
    output CAL, DONE, ERR;

    electrical [11:0] Bit;
    electrical [0:13] BP;
    electrical DGND, DVDD;
    electrical SOUT;
    electrical COMP, COMN;
    electrical RST1, CAL_RST, CAL_CLK;
    electrical CLK_SAR, CLK00, CLK;
    electrical [0:12] BITD_CAL, BITU_CAL;
    electrical CAL, DONE, ERR;

    parameter real VTH_FRACTION = 0.5 from (0.0:1.0);
    parameter real TD = 0.0 from [0.0:inf);
    parameter real TR = 20p from (0.0:inf);
    parameter real TF = 20p from (0.0:inf);
    parameter real TD_CAL = 200p from [0.0:inf);
    parameter real TD_CMP_CAL = 2n from [0.0:inf);
    parameter real RDRV_CLK = 1.0 from (0.0:inf);
    parameter integer CMP_SWAP = 1 from [0:1];
    parameter real CMP_VALID_FRACTION = 0.20 from (0.0:1.0);
    parameter integer MAX_INVALID = 3 from [0:inf);
    parameter integer FIRST_INVERT = 0 from [0:1];
    parameter integer RAW_INVERT = 0 from [0:1];
    // V6.3 review fix R2-4: integer percent (was real WEIGHT_TOL = 0.35).
    // Keeps tolerance comparison integer-exact, matching the RTL.
    parameter integer WEIGHT_TOL_PCT = 35 from [0:100];
    parameter integer DEBUG = 1 from [0:2];
    parameter integer FRAC_BITS = 6 from [0:8];

    // ===== USER-EDITABLE CALIBRATION DEFAULTS =====
    // CAL_BYPASS: 0 = run foreground calibration; 1 = bypass calibration.
    parameter integer CAL_BYPASS = 0 from [0:1];
    // Number of D+/D- measurement pairs is 2**AVG_PAIRS_LOG2:
    //   0->1, 1->2, 2->4, 3->8, 4->16, 5->32, ...
    parameter integer AVG_PAIRS_LOG2 = 5 from [0:8];
    // ENFORCE_MIN_AVG: 1 (default, safe) clamps AVG_PAIRS_LOG2 to at least
    //   MIN_AVG_PAIRS_LOG2, protecting old CDF/netlists that pass 0.
    parameter integer ENFORCE_MIN_AVG = 1 from [0:1];
    parameter integer MIN_AVG_PAIRS_LOG2 = 5 from [0:8];
    // APPLY_CAL_WEIGHT: 1 = use calibrated w0/w1/w2 in normal decoder.
    parameter integer APPLY_CAL_WEIGHT = 1 from [0:1];
    // V6.3 review fix R3-N: removed dead parameter REMOVE_REDUNDANCY_OFFSET.
    // Redundancy offset removal is always-on (centered_sum = raw_sum - offset),
    // the parameter was declared but never gated any logic.
    parameter integer WARN_ON_OUTPUT_CLIP = 1 from [0:1];
    parameter integer ZERO_ON_INVALID_PHASE0 = 1 from [0:1];
    // V6.3: Saturation rejection threshold (integer percent).
    // A target is rejected only if saturate_count*100 > SAT_RATIO_PCT*avg_pairs.
    parameter integer SAT_RATIO_PCT = 50 from [0:100];
    // ===============================================

    integer w0, w1, w2, w3, w4, w5, w6;
    integer w7, w8, w9, w10, w11, w12, w13;
    integer q_scale;
    integer weight_frac_bits;
    integer avg_pairs;

    integer cal_state;
    localparam CAL_IDLE       = 0;
    localparam CAL_PRECHARGE  = 1;
    localparam CAL_SAR_TRIAL  = 2;
    localparam CAL_TERMINAL   = 3;
    localparam CAL_FINISH_DIR = 4;

    integer sar_step;
    integer trial_mask;
    integer switched_mask;     // calDAC caps switched from 10 to 01
    integer switched_sum;      // sum of switched weights
    integer d_plus_code;
    integer d_minus_code;
    integer direction;
    integer target_idx;
    integer target_mask;
    integer wall_mask;
    integer caldac_mask;       // stages 6..12 = 0x1FC0 = 8128
    integer d_mask, u_mask;

    integer repeat_idx;
    integer accum_d_plus;
    integer accum_d_minus;

    integer cal_mode_i;
    integer cal_done_i;
    integer cal_error_i;
    integer cal_degraded_i;    // V6.3: at least one target rejected
    integer finish_pending_i;
    integer frame_active_i;
    integer invalid_count;
    integer zero_force_i;
    // V6.3 review P1-1/P1-2: per-pair saturation accounting.
    //   d_plus_saturated  : set when D+ code hits calDAC endpoint.
    //   pair_saturated    : OR of D+ and D- saturation for the current pair,
    //                       evaluated at D- completion.
    //   saturate_count    : number of saturated pairs (0..avg_pairs).
    //   valid_pair_count  : number of non-saturated pairs accumulated.
    // Saturated pairs are excluded from accum_d_plus/accum_d_minus; the
    // residual is computed over valid_pair_count only.
    integer d_plus_saturated;
    integer pair_saturated;
    integer saturate_count;
    integer valid_pair_count;
    integer target_rejected;  // V6.3: current target rejection flag

    integer measured_weight_q;
    integer wall_weight_q;
    integer residual_q;
    integer rounding_term;

    integer clk_sar_i;
    integer clk_cal_i;

    integer r0, r1, r2, r3, r4, r5, r6;
    integer r7, r8, r9, r10, r11, r12, r13;
    integer raw_sum;
    integer total_weight_q;
    integer dec_w0, dec_w1, dec_w2;
    integer redundancy_offset_q;
    integer centered_sum;
    integer adc_code;
    integer clip_low_i;
    integer clip_high_i;
    integer b0, b1, b2, b3, b4, b5;
    integer b6, b7, b8, b9, b10, b11;

    integer cmp_p_gt_n;
    integer cmp_valid;
    integer code_value;
    integer trial_w;           // trial weight for F+ diagnostic

    real vlogic;
    real vth;
    real cmp_delta;
    real cmp_valid_min;

    genvar g;

    analog begin
        vlogic = V(DVDD, DGND);
        vth = VTH_FRACTION * vlogic;
        cmp_valid_min = CMP_VALID_FRACTION * vlogic;

        @(initial_step) begin
            weight_frac_bits = (FRAC_BITS < 6) ? 6 : FRAC_BITS;
            q_scale = 1 << weight_frac_bits;
            avg_pairs = 1 << (((ENFORCE_MIN_AVG != 0) &&
                (AVG_PAIRS_LOG2 < MIN_AVG_PAIRS_LOG2)) ?
                MIN_AVG_PAIRS_LOG2 : AVG_PAIRS_LOG2);
            caldac_mask = 8128;

            cal_mode_i = 0;
            cal_done_i = 0;
            cal_error_i = 0;
            cal_degraded_i = 0;

            // V6.3: inline weight reset (no task for analog-block compat).
            w0 = 2048*q_scale; w1 = 1024*q_scale; w2 = 512*q_scale;
            w3 = 256*q_scale; w4 = 256*q_scale; w5 = 128*q_scale;
            w6 = 48*q_scale; w7 = 32*q_scale; w8 = 20*q_scale;
            w9 = 12*q_scale; w10 = 8*q_scale; w11 = 4*q_scale;
            w12 = 2*q_scale; w13 = q_scale;

            // V6.3: inline cal-state reset.
            cal_state = CAL_IDLE;
            sar_step = 0; trial_mask = 0; switched_mask = 0; switched_sum = 0;
            d_plus_code = 0; d_minus_code = 0; direction = 0;
            target_idx = 2; target_mask = 4; wall_mask = 24;
            d_mask = 0; u_mask = 0;
            repeat_idx = 0; accum_d_plus = 0; accum_d_minus = 0;
            finish_pending_i = 0; frame_active_i = 0;
            invalid_count = 0; zero_force_i = 0;
            saturate_count = 0; target_rejected = 0;
            d_plus_saturated = 0; pair_saturated = 0;
            valid_pair_count = 0;
            // V6.3 P0 fix: wall = W3+W4 (gauge=512) for first target (W2).
            // Initialized here so CAL_RST=0 at t=0 does not produce wall=0.
            wall_weight_q = w3 + w4;

            measured_weight_q = 0;
            residual_q = 0;
            adc_code = 0;

            if (CAL_BYPASS != 0) begin
                cal_mode_i = 0;
                cal_done_i = 1;
            end else if (V(CAL_RST, DGND) < vth) begin
                cal_mode_i = 1;
            end
        end

        // CAL_RST rising: reset.
        @(cross(V(CAL_RST, DGND) - vth, +1)) begin
            weight_frac_bits = (FRAC_BITS < 6) ? 6 : FRAC_BITS;
            q_scale = 1 << weight_frac_bits;
            avg_pairs = 1 << (((ENFORCE_MIN_AVG != 0) &&
                (AVG_PAIRS_LOG2 < MIN_AVG_PAIRS_LOG2)) ?
                MIN_AVG_PAIRS_LOG2 : AVG_PAIRS_LOG2);
            caldac_mask = 8128;

            cal_mode_i = 0;
            cal_done_i = (CAL_BYPASS != 0) ? 1 : 0;
            cal_error_i = 0;
            cal_degraded_i = 0;

            // V6.3: inline weight reset.
            w0 = 2048*q_scale; w1 = 1024*q_scale; w2 = 512*q_scale;
            w3 = 256*q_scale; w4 = 256*q_scale; w5 = 128*q_scale;
            w6 = 48*q_scale; w7 = 32*q_scale; w8 = 20*q_scale;
            w9 = 12*q_scale; w10 = 8*q_scale; w11 = 4*q_scale;
            w12 = 2*q_scale; w13 = q_scale;

            // V6.3: inline cal-state reset.
            cal_state = CAL_IDLE;
            sar_step = 0; trial_mask = 0; switched_mask = 0; switched_sum = 0;
            d_plus_code = 0; d_minus_code = 0; direction = 0;
            target_idx = 2; target_mask = 4; wall_mask = 24;
            d_mask = 0; u_mask = 0;
            repeat_idx = 0; accum_d_plus = 0; accum_d_minus = 0;
            finish_pending_i = 0; frame_active_i = 0;
            invalid_count = 0; zero_force_i = 0;
            saturate_count = 0; target_rejected = 0;
            d_plus_saturated = 0; pair_saturated = 0;
            valid_pair_count = 0;
            wall_weight_q = w3 + w4;
            adc_code = 0;
        end

        // CAL_RST falling: start calibration.
        @(cross(V(CAL_RST, DGND) - vth, -1)) begin
            if (CAL_BYPASS == 0) begin
                cal_mode_i = 1; cal_done_i = 0; cal_error_i = 0;
                cal_degraded_i = 0;

                // V6.3: inline cal-state reset (wall = W3+W4 gauge).
                cal_state = CAL_IDLE;
                sar_step = 0; trial_mask = 0; switched_mask = 0; switched_sum = 0;
                d_plus_code = 0; d_minus_code = 0; direction = 0;
                target_idx = 2; target_mask = 4; wall_mask = 24;
                d_mask = 0; u_mask = 0;
                repeat_idx = 0; accum_d_plus = 0; accum_d_minus = 0;
                finish_pending_i = 0; frame_active_i = 0;
                invalid_count = 0; zero_force_i = 0;
                saturate_count = 0; target_rejected = 0;
                d_plus_saturated = 0; pair_saturated = 0;
                valid_pair_count = 0;
                wall_weight_q = w3 + w4;

                if (DEBUG != 0)
                    $strobe("OFFSAR start t=%g avg_pairs=%0d Q=%0d targets=3 (gauge W3+W4=512)",
                        $abstime, avg_pairs, weight_frac_bits);
            end
        end

        // RST1 falling: start frame.
        @(cross(V(RST1, DGND) - vth, -1)) begin
            if ((cal_mode_i != 0) && (finish_pending_i == 0)) begin
                frame_active_i = 1;
                d_mask = 0; u_mask = 0;
                cal_state = CAL_PRECHARGE;
                sar_step = 0; trial_mask = 0;
                switched_mask = 0; switched_sum = 0;
                zero_force_i = 0;
                if (DEBUG > 1)
                    $strobe("OFFSAR frame start target=%0d dir=%0d pair=%0d t=%g",
                        target_idx, direction, repeat_idx, $abstime);
            end
        end

        // CAL_CLK rising: set up trial (switch one calDAC cap from 10 to 01).
        @(cross(V(CAL_CLK, DGND) - vth, +1)) begin
            if ((cal_mode_i != 0) && (frame_active_i != 0) &&
                (finish_pending_i == 0)) begin

                if (cal_state == CAL_PRECHARGE) begin
                    switched_mask = 0;
                    switched_sum = 0;
                    sar_step = 0;
                    cal_state = CAL_SAR_TRIAL;
                    trial_mask = 64;  // stage 6 = C7, weight 48
                end else if (cal_state == CAL_SAR_TRIAL) begin
                    case (sar_step)
                        0: trial_mask = 64;   // C7, w=48, stage 6
                        1: trial_mask = 128;  // C6, w=32, stage 7
                        2: trial_mask = 256;  // C5, w=20, stage 8
                        3: trial_mask = 512;  // C4, w=12, stage 9
                        4: trial_mask = 1024; // C3, w=8, stage 10
                        5: trial_mask = 2048; // C2, w=4, stage 11
                        6: trial_mask = 4096; // C1, w=2, stage 12
                        default: trial_mask = 0;
                    endcase
                end

                if (direction == 0) begin
                    d_mask = target_mask |
                             (caldac_mask & ~(switched_mask | trial_mask));
                    u_mask = wall_mask | switched_mask | trial_mask;
                end else begin
                    d_mask = wall_mask |
                             (caldac_mask & ~(switched_mask | trial_mask));
                    u_mask = target_mask | switched_mask | trial_mask;
                end
            end
        end

        // CAL_CLK falling: latch comparator, decide keep/undo.
        @(cross(V(CAL_CLK, DGND) - vth, -1)) begin
            if ((cal_mode_i != 0) && (frame_active_i != 0) &&
                (finish_pending_i == 0) && (cal_state != CAL_PRECHARGE)) begin

                cmp_delta = V(COMP, DGND) - V(COMN, DGND);
                if (cmp_delta < 0.0)
                    cmp_valid = ((-cmp_delta) > cmp_valid_min) ? 1 : 0;
                else
                    cmp_valid = (cmp_delta > cmp_valid_min) ? 1 : 0;

                if (cmp_valid == 0) begin
                    invalid_count = invalid_count + 1;
                    if (invalid_count > MAX_INVALID) begin
                        if (ZERO_ON_INVALID_PHASE0 != 0) begin
                            invalid_count = 0;
                            cmp_valid = 1;
                            if (cal_state == CAL_TERMINAL)
                                cmp_p_gt_n = 0;
                            else
                                cmp_p_gt_n = 1;
                            zero_force_i = 1;
                            if (DEBUG != 0)
                                $strobe("OFFSAR zero-hit target=%0d dir=%0d step=%0d state=%0d t=%g",
                                    target_idx, direction, sar_step, cal_state, $abstime);
                        end else begin
                            cal_error_i = 1;
                            finish_pending_i = 1;
                        end
                    end
                end

                if (cmp_valid != 0) begin
                    invalid_count = 0;
                    if (zero_force_i == 0) begin
                        cmp_p_gt_n = (V(COMP, DGND) < V(COMN, DGND)) ? 1 : 0;
                        if (CMP_SWAP != 0)
                            cmp_p_gt_n = 1 - cmp_p_gt_n;
                    end
                    zero_force_i = 0;

                    if (DEBUG > 1) begin
                        case (sar_step)
                            0: trial_w = 48;
                            1: trial_w = 32;
                            2: trial_w = 20;
                            3: trial_w = 12;
                            4: trial_w = 8;
                            5: trial_w = 4;
                            6: trial_w = 2;
                            default: trial_w = 0;
                        endcase
                        $strobe("OFFSAR CMPDIAG tgt=%0d dir=%0d st=%0d step=%0d S=%0d trW=%0d S_tr=%0d dmask=%0d umask=%0d CMPd=%gV cmp=%0d t=%g",
                            target_idx, direction, cal_state, sar_step,
                            switched_sum, trial_w, switched_sum + trial_w,
                            d_mask, u_mask, cmp_delta, cmp_p_gt_n, $abstime);
                    end

                    if (cal_state == CAL_SAR_TRIAL) begin
                        if (cmp_p_gt_n != 0) begin
                            switched_mask = switched_mask | trial_mask;
                            case (sar_step)
                                0: switched_sum = switched_sum + 48;
                                1: switched_sum = switched_sum + 32;
                                2: switched_sum = switched_sum + 20;
                                3: switched_sum = switched_sum + 12;
                                4: switched_sum = switched_sum + 8;
                                5: switched_sum = switched_sum + 4;
                                6: switched_sum = switched_sum + 2;
                            endcase
                        end

                        sar_step = sar_step + 1;
                        trial_mask = 0;

                        if (sar_step >= 7) begin
                            cal_state = CAL_TERMINAL;
                        end
                    end else if (cal_state == CAL_TERMINAL) begin
                        code_value = switched_sum + (cmp_p_gt_n != 0 ? 1 : 0);

                        if (direction == 0) begin
                            d_plus_code = code_value;
                            // V6.3 review P1-1: track D+ saturation as a
                            // per-pair flag (counter incremented at D-).
                            d_plus_saturated =
                                ((code_value >= 126) || (code_value <= 1)) ? 1 : 0;
                            if (DEBUG > 1)
                                $strobe("OFFSAR code target=%0d dir=+ D+=%0d switched=%0d bT=%0d t=%g",
                                    target_idx, d_plus_code, switched_sum,
                                    cmp_p_gt_n, $abstime);
                        end else begin
                            d_minus_code = code_value;
                            if (DEBUG > 1)
                                $strobe("OFFSAR code target=%0d dir=- D-=%0d switched=%0d bT=%0d t=%g",
                                    target_idx, d_minus_code, switched_sum,
                                    cmp_p_gt_n, $abstime);
                        end

                        // V6.3 review P1-1/P1-2: saturation accounting now
                        // per-pair. We only set d_plus_saturated here; the
                        // per-pair OR and counter increment happen at D-
                        // completion inside the RST1-rising handler. This
                        // avoids double-counting (was 2x avg_pairs max).
                        if (((code_value >= 126) || (code_value <= 1)) &&
                            (DEBUG != 0))
                            $strobe("OFFSAR SATURATE target=%0d dir=%0d code=%0d (endpoint) t=%g",
                                target_idx, direction, code_value, $abstime);

                        cal_state = CAL_FINISH_DIR;
                    end
                end
            end
        end

        // V6.3 P0-2 fix: SINGLE RST1-rising handler with explicit ordering.
        //   1) End current frame (frame_active_i = 0)
        //   2) If a direction just finished AND no finish is pending yet,
        //      consume it (compute weight, advance target, possibly set
        //      finish_pending_i = 1 on the last target).
        //   3) Independently (NOT else-if): if finish_pending_i is set,
        //      perform handoff on the SAME RST1 edge. This eliminates the
        //      extra-frame DONE delay the previous (else-if) structure had.
        //   The key invariant: step (2) may set finish_pending_i, and step
        //   (3) must observe that new value within the same event.
        @(cross(V(RST1, DGND) - vth, +1)) begin
            frame_active_i = 0;
            d_mask = 0; u_mask = 0;

            // (2) Direction finish: compute weight or switch direction.
            //     Guard with !finish_pending_i so we don't re-enter after
            //     a CMP_INVALID path or a previous target already set it.
            if ((cal_mode_i != 0) && (finish_pending_i == 0) &&
                (cal_state == CAL_FINISH_DIR)) begin
                if (direction == 0) begin
                    // D+ done, start D-.
                    direction = 1;
                    cal_state = CAL_IDLE;
                end else begin
                    // Both directions done, finalize one pair.
                    // V6.3 review P1-1: per-pair saturation OR.
                    // V6.3 review P1-2: saturated pairs excluded from
                    //                    accum and from the residual divisor.
                    pair_saturated = (d_plus_saturated != 0) ||
                        ((d_minus_code >= 126) || (d_minus_code <= 1));
                    if (pair_saturated == 0) begin
                        accum_d_plus  = accum_d_plus  + d_plus_code;
                        accum_d_minus = accum_d_minus + d_minus_code;
                        valid_pair_count = valid_pair_count + 1;
                    end else begin
                        saturate_count = saturate_count + 1;
                    end
                    repeat_idx = repeat_idx + 1;
                    d_plus_saturated = 0;

                    if (DEBUG > 1)
                        $strobe("OFFSAR pair target=%0d D+=%0d D-=%0d pair=%0d sat_pairs=%0d valid=%0d t=%g",
                            target_idx, d_plus_code, d_minus_code,
                            repeat_idx, saturate_count, valid_pair_count,
                            $abstime);

                    if (repeat_idx >= avg_pairs) begin
                        // Q-format: R_Q = round(q_scale * (sum_D+ - sum_D-) / N)
                        // Divisor is valid_pair_count (non-saturated pairs).
                        // If all pairs saturated, residual is undefined → reject.
                        if (valid_pair_count == 0) begin
                            target_rejected = 1;
                            residual_q = 0;
                            measured_weight_q = wall_weight_q;
                            if (DEBUG != 0)
                                $strobe("OFFSAR REJECT target=%0d all_pairs_saturated sat=%0d/%0d t=%g",
                                    target_idx, saturate_count, avg_pairs,
                                    $abstime);
                        end else begin
                            if ((accum_d_plus - accum_d_minus) >= 0)
                                rounding_term = valid_pair_count / 2;
                            else
                                rounding_term = -valid_pair_count / 2;
                            residual_q = (q_scale * (accum_d_plus - accum_d_minus)
                                + rounding_term) / valid_pair_count;

                            measured_weight_q = wall_weight_q + residual_q;

                            // V6.3 review P1-1: per-pair saturation test.
                            // saturate_count is now in [0..avg_pairs]; the
                            // threshold compare uses avg_pairs as denominator.
                            if (saturate_count * 100 > SAT_RATIO_PCT * avg_pairs) begin
                                target_rejected = 1;
                                if (DEBUG != 0)
                                    $strobe("OFFSAR REJECT target=%0d measured_q=%0d sat_pairs=%0d/%0d (> %0d%%) t=%g",
                                        target_idx, measured_weight_q,
                                        saturate_count, avg_pairs,
                                        SAT_RATIO_PCT, $abstime);
                            end else begin
                                // Per-target tolerance window (inline, no macros).
                                case (target_idx)
                                    2: begin
                                        // V6.3 review fix R2-4: integer percent compare.
                                        if ((measured_weight_q * 100 >= 512*q_scale*(100 - WEIGHT_TOL_PCT)) &&
                                            (measured_weight_q * 100 <= 512*q_scale*(100 + WEIGHT_TOL_PCT))) begin
                                            w2 = measured_weight_q;
                                            if (DEBUG != 0)
                                                $strobe("OFFSAR measure target=2 wall_q=%0d R_q=%0d measured_q=%0d valid=%0d/%0d ACCEPT t=%g",
                                                    wall_weight_q, residual_q,
                                                    measured_weight_q,
                                                    valid_pair_count, avg_pairs,
                                                    $abstime);
                                        end else
                                            target_rejected = 1;
                                    end
                                    1: begin
                                        if ((measured_weight_q * 100 >= 1024*q_scale*(100 - WEIGHT_TOL_PCT)) &&
                                            (measured_weight_q * 100 <= 1024*q_scale*(100 + WEIGHT_TOL_PCT))) begin
                                            w1 = measured_weight_q;
                                            if (DEBUG != 0)
                                                $strobe("OFFSAR measure target=1 wall_q=%0d R_q=%0d measured_q=%0d valid=%0d/%0d ACCEPT t=%g",
                                                    wall_weight_q, residual_q,
                                                    measured_weight_q,
                                                    valid_pair_count, avg_pairs,
                                                    $abstime);
                                        end else
                                            target_rejected = 1;
                                    end
                                    0: begin
                                        if ((measured_weight_q * 100 >= 2048*q_scale*(100 - WEIGHT_TOL_PCT)) &&
                                            (measured_weight_q * 100 <= 2048*q_scale*(100 + WEIGHT_TOL_PCT))) begin
                                            w0 = measured_weight_q;
                                            if (DEBUG != 0)
                                                $strobe("OFFSAR measure target=0 wall_q=%0d R_q=%0d measured_q=%0d valid=%0d/%0d ACCEPT t=%g",
                                                    wall_weight_q, residual_q,
                                                    measured_weight_q,
                                                    valid_pair_count, avg_pairs,
                                                    $abstime);
                                        end else
                                            target_rejected = 1;
                                    end
                                    default: target_rejected = 1;
                                endcase
                                if ((target_rejected != 0) && (DEBUG != 0))
                                    $strobe("OFFSAR REJECT target=%0d measured_q=%0d out-of-tolerance (tol_pct=%0d%%) t=%g",
                                        target_idx, measured_weight_q,
                                        WEIGHT_TOL_PCT, $abstime);
                            end
                        end

                        // V6.3: if rejected, mark degraded. Downstream
                        // targets still run with the nominal weight
                        // (calibrated update is skipped for rejected targets
                        // only). Normal decoder falls back to nominal weights
                        // when ERR=1 (see P1-4 fix below).
                        if (target_rejected != 0) begin
                            cal_degraded_i = 1;
                            target_rejected = 0;
                        end

                        // Advance to next target.
                        target_idx = target_idx - 1;
                        repeat_idx = 0;
                        accum_d_plus = 0;
                        accum_d_minus = 0;
                        saturate_count = 0;
                        valid_pair_count = 0;
                        d_plus_saturated = 0;
                        pair_saturated = 0;

                        case (target_idx)
                            1: begin
                                // Next: W1, wall = W2+W3+W4
                                target_mask = 2;
                                wall_mask = 28;  // stages 2,3,4
                                wall_weight_q = w2 + w3 + w4;
                            end
                            0: begin
                                // Next: W0, wall = W1+W2+W3+W4
                                target_mask = 1;
                                wall_mask = 30;  // stages 1,2,3,4
                                wall_weight_q = w1 + w2 + w3 + w4;
                            end
                            default: begin
                                finish_pending_i = 1;
                                target_idx = -1;
                            end
                        endcase
                        direction = 0;
                    end else begin
                        direction = 0;
                    end
                    cal_state = CAL_IDLE;
                end
            end

            // (3) Handoff: calibration complete. Independent if (NOT else-if)
            //     so it can fire on the SAME RST1 edge where the last target
            //     just set finish_pending_i = 1 in step (2) above.
            if ((cal_mode_i != 0) && (finish_pending_i != 0)) begin
                cal_mode_i = 0;
                if (cal_error_i != 0) begin
                    // Hard error: restore nominal weights.
                    w0 = 2048*q_scale; w1 = 1024*q_scale; w2 = 512*q_scale;
                    w3 = 256*q_scale; w4 = 256*q_scale; w5 = 128*q_scale;
                    w6 = 48*q_scale; w7 = 32*q_scale; w8 = 20*q_scale;
                    w9 = 12*q_scale; w10 = 8*q_scale; w11 = 4*q_scale;
                    w12 = 2*q_scale; w13 = q_scale;
                end
                // V6.3: degraded (any target rejected) reports ERR=1.
                // The normal decoder (see SOUT handler) gates calibrated
                // weight application on cal_error_i == 0, so a degraded
                // run causes the decoder to fall back to nominal weights
                // (no partial-cal application). This makes "caller can
                // decide" actually true: ERR=1 → decoder uses nominal.
                if (cal_degraded_i != 0)
                    cal_error_i = 1;
                cal_done_i = 1;
                if (DEBUG != 0) begin
                    $strobe("OFFSAR finish t=%g done=%0d err=%0d degraded=%0d",
                        $abstime, cal_done_i, cal_error_i, cal_degraded_i);
                    $strobe("OFFSAR weights_q={%0d,%0d,%0d,%0d,%0d,%0d,%0d,%0d,%0d,%0d,%0d,%0d,%0d,%0d} Q=%0d",
                        w0, w1, w2, w3, w4, w5, w6, w7, w8,
                        w9, w10, w11, w12, w13, weight_frac_bits);
                end
            end
        end

        // Decode the two clock inputs into piecewise-constant integers.
        clk_sar_i = (V(CLK_SAR, DGND) > vth) ? 1 : 0;
        clk_cal_i = (V(CAL_CLK, DGND) > vth) ? 1 : 0;

        // Normal decoder: latch one completed RAW conversion only on SOUT.
        @(cross(V(SOUT, DGND) - vth, +1)) begin
            if ((CAL_BYPASS != 0) ||
                ((cal_done_i != 0) && (cal_mode_i == 0))) begin
                r0  = (V(BP[13], DGND) > vth) ? 1 : 0;
                r1  = (V(BP[12], DGND) > vth) ? 1 : 0;
                r2  = (V(BP[11], DGND) > vth) ? 1 : 0;
                r3  = (V(BP[10], DGND) > vth) ? 1 : 0;
                r4  = (V(BP[9],  DGND) > vth) ? 1 : 0;
                r5  = (V(BP[8],  DGND) > vth) ? 1 : 0;
                r6  = (V(BP[7],  DGND) > vth) ? 1 : 0;
                r7  = (V(BP[6],  DGND) > vth) ? 1 : 0;
                r8  = (V(BP[5],  DGND) > vth) ? 1 : 0;
                r9  = (V(BP[4],  DGND) > vth) ? 1 : 0;
                r10 = (V(BP[3],  DGND) > vth) ? 1 : 0;
                r11 = (V(BP[2],  DGND) > vth) ? 1 : 0;
                r12 = (V(BP[1],  DGND) > vth) ? 1 : 0;
                r13 = (V(BP[0],  DGND) > vth) ? 1 : 0;

                if (RAW_INVERT != 0) begin
                    r1 = 1-r1;   r2 = 1-r2;   r3 = 1-r3;
                    r4 = 1-r4;   r5 = 1-r5;   r6 = 1-r6;
                    r7 = 1-r7;   r8 = 1-r8;   r9 = 1-r9;
                    r10 = 1-r10; r11 = 1-r11; r12 = 1-r12;
                    r13 = 1-r13;
                end
                if (FIRST_INVERT != 0)
                    r0 = 1-r0;

                // V6.3 review P1-4: decoder fail policy. Calibrated weights
                // are applied ONLY when (a) the user has enabled APPLY_CAL_WEIGHT
                // AND (b) calibration completed without error (cal_error_i == 0).
                // If ERR=1 (degraded or hard error), the decoder falls back to
                // nominal weights — partial calibration is NOT silently applied.
                // This makes the "caller can decide" contract honest: ERR=1
                // means the decoder is using nominal weights, not partial.
                if ((APPLY_CAL_WEIGHT != 0) && (cal_error_i == 0)) begin
                    dec_w0 = w0; dec_w1 = w1; dec_w2 = w2;
                end else begin
                    dec_w0 = 2048*q_scale;
                    dec_w1 = 1024*q_scale;
                    dec_w2 = 512*q_scale;
                end

                raw_sum = r0*dec_w0 + r1*dec_w1 + r2*dec_w2 +
                    r3*w3 + r4*w4 + r5*w5 + r6*w6 + r7*w7 +
                    r8*w8 + r9*w9 + r10*w10 + r11*w11 +
                    r12*w12 + r13*w13;

                total_weight_q = dec_w0 + dec_w1 + dec_w2 +
                    w3 + w4 + w5 + w6 + w7 + w8 + w9 +
                    w10 + w11 + w12 + w13;

                // Symmetric redundancy offset removal (no normalization).
                redundancy_offset_q = total_weight_q - 4095*q_scale;
                if (redundancy_offset_q >= 0)
                    redundancy_offset_q = (redundancy_offset_q + 1)/2;
                else
                    redundancy_offset_q = (redundancy_offset_q - 1)/2;
                centered_sum = raw_sum - redundancy_offset_q;

                if (centered_sum >= 0)
                    adc_code = (centered_sum + q_scale/2) / q_scale;
                else
                    adc_code = (centered_sum - q_scale/2) / q_scale;

                clip_low_i = 0;
                clip_high_i = 0;
                if (adc_code < 0) begin
                    adc_code = 0;
                    clip_low_i = 1;
                end else if (adc_code > 4095) begin
                    adc_code = 4095;
                    clip_high_i = 1;
                end

                if ((DEBUG != 0) && (WARN_ON_OUTPUT_CLIP != 0) &&
                    ((clip_low_i != 0) || (clip_high_i != 0)))
                    $strobe("OFFSAR decode clip t=%g raw_q=%0d total_q=%0d center_q=%0d code=%0d low=%0d high=%0d",
                        $abstime, raw_sum, total_weight_q, redundancy_offset_q,
                        adc_code, clip_low_i, clip_high_i);
            end
        end

        b0  = (adc_code      ) & 1;
        b1  = (adc_code >>  1) & 1;
        b2  = (adc_code >>  2) & 1;
        b3  = (adc_code >>  3) & 1;
        b4  = (adc_code >>  4) & 1;
        b5  = (adc_code >>  5) & 1;
        b6  = (adc_code >>  6) & 1;
        b7  = (adc_code >>  7) & 1;
        b8  = (adc_code >>  8) & 1;
        b9  = (adc_code >>  9) & 1;
        b10 = (adc_code >> 10) & 1;
        b11 = (adc_code >> 11) & 1;

        V(CAL,  DGND) <+ vlogic * transition(cal_mode_i,  TD, TR, TF);
        V(DONE, DGND) <+ vlogic * transition(cal_done_i,  TD, TR, TF);
        V(ERR,  DGND) <+ vlogic * transition(cal_error_i, TD, TR, TF);

        I(CLK, DGND) <+ (V(CLK, DGND) - vlogic * (
            (1 - cal_mode_i) * transition(clk_sar_i, TD, TR, TF) +
            cal_mode_i * transition(frame_active_i * clk_cal_i,
                                    TD_CMP_CAL, TR, TF)))
            / RDRV_CLK;

        V(Bit[0],  DGND) <+ vlogic * transition(b0,  TD, TR, TF);
        V(Bit[1],  DGND) <+ vlogic * transition(b1,  TD, TR, TF);
        V(Bit[2],  DGND) <+ vlogic * transition(b2,  TD, TR, TF);
        V(Bit[3],  DGND) <+ vlogic * transition(b3,  TD, TR, TF);
        V(Bit[4],  DGND) <+ vlogic * transition(b4,  TD, TR, TF);
        V(Bit[5],  DGND) <+ vlogic * transition(b5,  TD, TR, TF);
        V(Bit[6],  DGND) <+ vlogic * transition(b6,  TD, TR, TF);
        V(Bit[7],  DGND) <+ vlogic * transition(b7,  TD, TR, TF);
        V(Bit[8],  DGND) <+ vlogic * transition(b8,  TD, TR, TF);
        V(Bit[9],  DGND) <+ vlogic * transition(b9,  TD, TR, TF);
        V(Bit[10], DGND) <+ vlogic * transition(b10, TD, TR, TF);
        V(Bit[11], DGND) <+ vlogic * transition(b11, TD, TR, TF);

        for (g = 0; g <= 12; g = g + 1) begin
            V(BITD_CAL[g], DGND) <+ vlogic * transition(
                cal_mode_i * ((d_mask >> g) & 1), TD_CAL, TR, TF);
            V(BITU_CAL[g], DGND) <+ vlogic * transition(
                cal_mode_i * ((u_mask >> g) & 1), TD_CAL, TR, TF);
        end
    end
endmodule
