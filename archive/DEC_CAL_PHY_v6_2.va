// Clean V6 offset-binary foreground calibration and calibrated decoder for
// test_12bit50MSAR_AMS_final_0716.
//
// V6: 7-bit calDAC (stages 6-12), range ±126, SAR 7 steps, DITHER_PAIR_EDGES=16
// V6.1: 4-target recursive calibration with w3+w4 joint measurement
//   Added target_idx=3 (w2) and target_idx=2 (w3+w4 joint) to eliminate
//   the 1/2/4x propagation of E=e3+e4 into w2/w1/w0.
//   Target sequence: w2(512) -> w3+w4(512 joint) -> w1(1024) -> w0(2048)
//   calDAC range, SAR steps, and DITHER_PAIR_EDGES unchanged.
// V6.2: w2 re-correction + calDAC saturation detection
//   1) After measuring w3+w4 (target_idx=2), add E=(measured-512) back to w2.
//      This fully eliminates the -E residual error in w2/w1/w0 that V6.1 left.
//      Math: w2_measured = 512+e2-E (wall was nominal w3+w4).
//             measured_34 = 512+E (wall was w2_measured, residual = 2E-e2).
//             w2_corrected = w2_measured + E = 512+e2 (exact).
//   2) Track saturate_flag when D+/D- code hits endpoint (>=126 or <=1).
//      Reject saturated measurements (skip weight update) to prevent silent
//      acceptance of out-of-range residuals that pass the ±35% tolerance.
//
// REQUIRED CLOCK TOPOLOGY:
//   SYNC_asnyc symbol terminal CLK -> net CLK_SAR
//   DEC_CAL_PHY output CLK         -> final comparator net CLK
//   COM_ideal CLK                  -> final comparator net CLK
// No other module may drive final net CLK.
//
// Alignment contract with SWITCH_CAL_aligned_v5:
//   * RST1 precharges/releases the physical CDAC top plates once per frame;
//   * CAL_CLK only advances trials and clocks the external comparator;
//   * BITD_CAL/BITU_CAL are conversion-stage ordered: stage 0 -> physical 13;
//   * 10 is positive, 01 is negative, and 00/11 are VCM;
//   * target sequence is C10(stage2), C11(stage1), C12(stage0).
//
// CORRECT Huang 2024 algorithm implementation:
//   * wall residual: R = W_target - W_wall
//   * offset-binary SAR: calDAC starts all-10 (+126), switches to 01
//   * trial COUNTER-DIRECTED to residual (SAR converges)
//   * D+ and D- are complete offset-binary codes (0..127)
//   * R = D+ - D-  (comparator offset cancels)
//   * Q-format averaging preserves sub-LSB info
//   * terminal bit is REAL comparator decision
//
// SWITCH_CAL encoding:
//   10 -> +contribution, 01 -> -contribution, 00 -> VCM
//
// offset-binary SAR:
//   Initial: all calDAC at 10 -> calDAC_out = +126
//   Switch cap from 10 to 01 -> calDAC_out -= 2*weight
//   Residual = R + calDAC_out, P>N(keep), P<N(undo)
//   D = sum(switched_weights) + b_T

`include "constants.vams"
`include "disciplines.vams"

module DEC_CAL_PHY (
    Bit, BP, DGND, DVDD, SOUT,
    COMP, COMN, RST1, CAL_RST,
    CLK_SAR, CLK00, CLK,
    BITD_CAL, BITU_CAL,
    CAL, DONE, ERR, CAL_CLK
);

    output [11:0] Bit;
    input  [0:13] BP;
    inout  DGND, DVDD;
    input  SOUT;
    input  COMP, COMN;
    input  RST1, CAL_RST;
    input  CLK_SAR, CLK00;
    input  CAL_CLK;
    output CLK;
    output [0:12] BITD_CAL, BITU_CAL;
    output CAL, DONE, ERR;

    electrical [11:0] Bit;
    electrical [0:13] BP;
    electrical DGND, DVDD;
    electrical SOUT;
    electrical COMP, COMN;
    electrical RST1, CAL_RST, CAL_CLK;
    electrical CLK_SAR, CLK00, CLK;
    electrical [0:12] BITD_CAL, BITU_CAL;
    electrical CAL, DONE, ERR;

    parameter real VTH_FRACTION = 0.5 from (0.0:1.0);
    parameter real TD = 0.0 from [0.0:inf);
    parameter real TR = 20p from (0.0:inf);
    parameter real TF = 20p from (0.0:inf);
    parameter real TD_CAL = 200p from [0.0:inf);
    parameter real TD_CMP_CAL = 2n from [0.0:inf);
    parameter real RDRV_CLK = 1.0 from (0.0:inf);
    parameter integer CMP_SWAP = 1 from [0:1];
    parameter real CMP_VALID_FRACTION = 0.20 from (0.0:1.0);
    parameter integer MAX_INVALID = 3 from [0:inf);
    parameter integer FIRST_INVERT = 0 from [0:1];
    parameter integer RAW_INVERT = 0 from [0:1];
    parameter real WEIGHT_TOL = 0.35 from (0.0:1.0);
    parameter integer DEBUG = 1 from [0:2];
    parameter integer FRAC_BITS = 6 from [0:8];

    // ===== USER-EDITABLE CALIBRATION DEFAULTS =====
    // CAL_BYPASS: 0 = run foreground calibration; 1 = bypass calibration.
    parameter integer CAL_BYPASS = 0 from [0:1];
    // Number of D+/D- measurement pairs is 2**AVG_PAIRS_LOG2:
    //   0->1, 1->2, 2->4, 3->8, 4->16, 5->32, ...
    parameter integer AVG_PAIRS_LOG2 = 5 from [0:8];
    // ENFORCE_MIN_AVG: 1 (default, safe) clamps AVG_PAIRS_LOG2 to at least
    //   MIN_AVG_PAIRS_LOG2, protecting old CDF/netlists that pass 0.
    //   Set to 0 to allow quick tests with fewer pairs (e.g. AVG_PAIRS_LOG2=0
    //   for 1-pair fast verification).
    parameter integer ENFORCE_MIN_AVG = 1 from [0:1];
    parameter integer MIN_AVG_PAIRS_LOG2 = 5 from [0:8];
    // ===============================================
    parameter integer APPLY_CAL_WEIGHT = 1 from [0:1];
    parameter integer REMOVE_REDUNDANCY_OFFSET = 1 from [0:1];
    parameter integer WARN_ON_OUTPUT_CLIP = 1 from [0:1];
    parameter integer ZERO_ON_INVALID_PHASE0 = 1 from [0:1];
    parameter integer ZERO_ON_INVALID_PHASE1 = 1 from [0:1];
    parameter real UPDATE_DEADBAND_LSB = 0.0 from [0.0:inf);
    parameter real HIGH_WEIGHT_UPDATE_DEADBAND_LSB = 0.0 from [0.0:inf);
    parameter integer APPLY_BIN_MIDPOINT = 0 from [0:1];
    parameter integer AUTO_BIN_MIDPOINT = 0 from [0:1];
    parameter integer SINGLE_PAIR_NOMINAL_GUARD = 0 from [0:1];
    parameter real SINGLE_PAIR_AMBIGUITY_LSB = 0.0 from [0.0:inf);
    parameter integer AVG_LOG2 = 3 from [0:8];
    parameter integer CAL_C7 = 0 from [0:1];
    parameter integer NORMALIZE_REDUNDANT_RANGE = 0 from [0:1];

    integer w0, w1, w2, w3, w4, w5, w6;
    integer w7, w8, w9, w10, w11, w12, w13;
    integer q_scale;
    integer weight_frac_bits;
    integer avg_pairs;

    integer cal_state;
    localparam CAL_IDLE       = 0;
    localparam CAL_PRECHARGE  = 1;
    localparam CAL_SAR_TRIAL  = 2;
    localparam CAL_TERMINAL   = 3;
    localparam CAL_FINISH_DIR = 4;

    integer sar_step;
    integer trial_mask;
    integer switched_mask;     // calDAC caps switched from 10 to 01
    integer switched_sum;      // sum of switched weights
    integer d_plus_code;
    integer d_minus_code;
    integer direction;
    integer target_idx;
    integer target_mask;
    integer wall_mask;
    integer caldac_mask;       // stages 6..12 = 0x1FC0 = 8128
    integer d_mask, u_mask;

    integer repeat_idx;
    integer accum_d_plus;
    integer accum_d_minus;

    integer cal_mode_i;
    integer cal_done_i;
    integer cal_error_i;
    integer cal_armed_i;
    integer cal_started_i;
    integer finish_pending_i;
    integer frame_active_i;
    integer invalid_count;
    integer zero_force_i;
    integer saturate_flag;   // V6.2: set when D+/D- hits endpoint (>=126 or <=1)

    integer measured_weight_q;
    integer wall_weight_q;
    integer residual_q;
    integer rounding_term;

    integer clk_sar_i;
    integer clk_cal_i;
    integer clk00_i;

    integer r0, r1, r2, r3, r4, r5, r6;
    integer r7, r8, r9, r10, r11, r12, r13;
    integer raw_sum;
    integer total_weight_q;
    integer dec_w0, dec_w1, dec_w2;
    integer redundancy_offset_q;
    integer centered_sum;
    integer adc_code;
    integer clip_low_i;
    integer clip_high_i;
    integer b0, b1, b2, b3, b4, b5;
    integer b6, b7, b8, b9, b10, b11;

    integer cmp_p_gt_n;
    integer cmp_valid;
    integer code_value;
    integer trial_w;           // trial weight for F+ diagnostic

    real vlogic;
    real vth;
    real cmp_delta;
    real cmp_valid_min;
    real scaled_code;

    genvar g;

    analog begin
        vlogic = V(DVDD, DGND);
        vth = VTH_FRACTION * vlogic;
        cmp_valid_min = CMP_VALID_FRACTION * vlogic;

        @(initial_step) begin
            weight_frac_bits = (FRAC_BITS < 6) ? 6 : FRAC_BITS;
            q_scale = 1 << weight_frac_bits;
            avg_pairs = 1 << (((ENFORCE_MIN_AVG != 0) &&
                (AVG_PAIRS_LOG2 < MIN_AVG_PAIRS_LOG2)) ?
                MIN_AVG_PAIRS_LOG2 : AVG_PAIRS_LOG2);
            caldac_mask = 8128;

            cal_state = CAL_IDLE;
            sar_step = 0;
            trial_mask = 0;
            switched_mask = 0;
            switched_sum = 0;
            d_plus_code = 0;
            d_minus_code = 0;
            direction = 0;
            target_idx = 3;
            target_mask = 4;
            wall_mask = 24;
            d_mask = 0;
            u_mask = 0;
            repeat_idx = 0;
            accum_d_plus = 0;
            accum_d_minus = 0;

            cal_mode_i = 0;
            cal_done_i = 0;
            cal_error_i = 0;
            cal_armed_i = 0;
            cal_started_i = 0;
            finish_pending_i = 0;
            frame_active_i = 0;
            invalid_count = 0;
            zero_force_i = 0;
            saturate_flag = 0;

            w0 = 2048*q_scale; w1 = 1024*q_scale; w2 = 512*q_scale;
            w3 = 256*q_scale; w4 = 256*q_scale; w5 = 128*q_scale;
            w6 = 48*q_scale; w7 = 32*q_scale; w8 = 20*q_scale;
            w9 = 12*q_scale; w10 = 8*q_scale; w11 = 4*q_scale;
            w12 = 2*q_scale; w13 = q_scale;

            measured_weight_q = 0;
            wall_weight_q = 0;
            residual_q = 0;
            adc_code = 0;

            if (CAL_BYPASS != 0) begin
                cal_mode_i = 0;
                cal_done_i = 1;
            end else if (V(CAL_RST, DGND) < vth) begin
                cal_mode_i = 1;
                cal_armed_i = 1;
            end
        end

        // CAL_RST rising: reset.
        @(cross(V(CAL_RST, DGND) - vth, +1)) begin
            weight_frac_bits = (FRAC_BITS < 6) ? 6 : FRAC_BITS;
            q_scale = 1 << weight_frac_bits;
            avg_pairs = 1 << (((ENFORCE_MIN_AVG != 0) &&
                (AVG_PAIRS_LOG2 < MIN_AVG_PAIRS_LOG2)) ?
                MIN_AVG_PAIRS_LOG2 : AVG_PAIRS_LOG2);
            caldac_mask = 8128;

            cal_state = CAL_IDLE;
            sar_step = 0; trial_mask = 0; switched_mask = 0; switched_sum = 0;
            d_plus_code = 0; d_minus_code = 0; direction = 0;
            target_idx = 3; target_mask = 4; wall_mask = 24;
            d_mask = 0; u_mask = 0;
            repeat_idx = 0; accum_d_plus = 0; accum_d_minus = 0;

            cal_mode_i = 0;
            cal_done_i = (CAL_BYPASS != 0) ? 1 : 0;
            cal_error_i = 0; cal_armed_i = 0; cal_started_i = 0;
            finish_pending_i = 0; frame_active_i = 0;
            invalid_count = 0; zero_force_i = 0; saturate_flag = 0;

            w0 = 2048*q_scale; w1 = 1024*q_scale; w2 = 512*q_scale;
            w3 = 256*q_scale; w4 = 256*q_scale; w5 = 128*q_scale;
            w6 = 48*q_scale; w7 = 32*q_scale; w8 = 20*q_scale;
            w9 = 12*q_scale; w10 = 8*q_scale; w11 = 4*q_scale;
            w12 = 2*q_scale; w13 = q_scale;
            adc_code = 0;
        end

        // CAL_RST falling: start calibration.
        @(cross(V(CAL_RST, DGND) - vth, -1)) begin
            if (CAL_BYPASS == 0) begin
                cal_state = CAL_IDLE;
                sar_step = 0; trial_mask = 0; switched_mask = 0; switched_sum = 0;
                d_plus_code = 0; d_minus_code = 0; direction = 0;
                target_idx = 3; target_mask = 4; wall_mask = 24;
                d_mask = 0; u_mask = 0;
                repeat_idx = 0; accum_d_plus = 0; accum_d_minus = 0;

                cal_mode_i = 1; cal_done_i = 0; cal_error_i = 0;
                cal_armed_i = 1; cal_started_i = 0;
                finish_pending_i = 0; frame_active_i = 0;
                invalid_count = 0; zero_force_i = 0; saturate_flag = 0;

                wall_weight_q = w3 + w4;
                if (DEBUG != 0)
                    $strobe("OFFSAR start t=%g avg_pairs=%0d Q=%0d",
                        $abstime, avg_pairs, weight_frac_bits);
            end
        end

        // RST1 rising: end frame, handoff.
        @(cross(V(RST1, DGND) - vth, +1)) begin
            frame_active_i = 0;
            cal_started_i = 0;
            d_mask = 0; u_mask = 0;
            if ((cal_mode_i != 0) && (finish_pending_i != 0)) begin
                cal_mode_i = 0; cal_armed_i = 0; cal_started_i = 0;
                d_mask = 0; u_mask = 0;
                if (cal_error_i != 0) begin
                    w0 = 2048*q_scale; w1 = 1024*q_scale; w2 = 512*q_scale;
                    w3 = 256*q_scale; w4 = 256*q_scale; w5 = 128*q_scale;
                    w6 = 48*q_scale; w7 = 32*q_scale; w8 = 20*q_scale;
                    w9 = 12*q_scale; w10 = 8*q_scale; w11 = 4*q_scale;
                    w12 = 2*q_scale; w13 = q_scale;
                end
                cal_done_i = 1;
                if (DEBUG != 0) begin
                    $strobe("OFFSAR finish t=%g done=%0d err=%0d",
                        $abstime, cal_done_i, cal_error_i);
                    $strobe("OFFSAR weights_q={%0d,%0d,%0d,%0d,%0d,%0d,%0d,%0d,%0d,%0d,%0d,%0d,%0d,%0d} Q=%0d",
                        w0, w1, w2, w3, w4, w5, w6, w7, w8,
                        w9, w10, w11, w12, w13, weight_frac_bits);
                end
            end
        end

        // RST1 falling: start frame.
        @(cross(V(RST1, DGND) - vth, -1)) begin
            if ((cal_mode_i != 0) && (finish_pending_i == 0)) begin
                frame_active_i = 1;
                cal_started_i = 0;
                d_mask = 0; u_mask = 0;
                cal_state = CAL_PRECHARGE;
                sar_step = 0; trial_mask = 0;
                switched_mask = 0; switched_sum = 0;
                zero_force_i = 0;
                if (DEBUG > 1)
                    $strobe("OFFSAR frame start target=%0d dir=%0d pair=%0d t=%g",
                        target_idx, direction, repeat_idx, $abstime);
            end
        end

        // CAL_CLK rising: set up trial (switch one calDAC cap from 10 to 01).
        @(cross(V(CAL_CLK, DGND) - vth, +1)) begin
            if ((cal_mode_i != 0) && (frame_active_i != 0) &&
                (finish_pending_i == 0)) begin

                if (cal_state == CAL_PRECHARGE) begin
                    // First evaluate: set up initial state + first trial.
                    switched_mask = 0;
                    switched_sum = 0;
                    sar_step = 0;
                    cal_state = CAL_SAR_TRIAL;
                    trial_mask = 64;  // stage 6 = C7, weight 48
                end else if (cal_state == CAL_SAR_TRIAL) begin
                    // Set trial for current sar_step.
                    case (sar_step)
                        0: trial_mask = 64;   // C7, w=48, stage 6
                        1: trial_mask = 128;  // C6, w=32, stage 7
                        2: trial_mask = 256;  // C5, w=20, stage 8
                        3: trial_mask = 512;  // C4, w=12, stage 9
                        4: trial_mask = 1024; // C3, w=8, stage 10
                        5: trial_mask = 2048; // C2, w=4, stage 11
                        6: trial_mask = 4096; // C1, w=2, stage 12
                        default: trial_mask = 0;
                    endcase
                end
                // CAL_TERMINAL: no trial, just evaluate with current switched_mask.

                // Update d_mask/u_mask.
                // Offset-binary polarity used by the SAR decision below:
                //   unswitched calDAC caps -> 10 (+w)
                //   switched/trial caps    -> 01 (-w)
                // Therefore Vcal = +126 - 2*S and every accepted trial
                // decreases the comparator residue.  The existing decision
                // "cmp_p_gt_n == 1 -> keep" is then a standard SAR decision.
                if (direction == 0) begin
                    // D+: F+ = +Wtarget - Wwall + 126 - 2*S
                    d_mask = target_mask |
                             (caldac_mask & ~(switched_mask | trial_mask));
                    u_mask = wall_mask | switched_mask | trial_mask;
                end else begin
                    // D-: F- = -Wtarget + Wwall + 126 - 2*S
                    d_mask = wall_mask |
                             (caldac_mask & ~(switched_mask | trial_mask));
                    u_mask = target_mask | switched_mask | trial_mask;
                end
            end
        end

        // CAL_CLK falling: latch comparator, decide keep/undo.
        @(cross(V(CAL_CLK, DGND) - vth, -1)) begin
            if ((cal_mode_i != 0) && (frame_active_i != 0) &&
                (finish_pending_i == 0) && (cal_state != CAL_PRECHARGE)) begin

                // Read comparator.
                cmp_delta = V(COMP, DGND) - V(COMN, DGND);
                if (cmp_delta < 0.0)
                    cmp_valid = ((-cmp_delta) > cmp_valid_min) ? 1 : 0;
                else
                    cmp_valid = (cmp_delta > cmp_valid_min) ? 1 : 0;

                if (cmp_valid == 0) begin
                    invalid_count = invalid_count + 1;
                    if (invalid_count > MAX_INVALID) begin
                        if (ZERO_ON_INVALID_PHASE0 != 0) begin
                            invalid_count = 0;
                            cmp_valid = 1;
                            if (cal_state == CAL_TERMINAL)
                                cmp_p_gt_n = 0;  // terminal: exact hit
                            else
                                cmp_p_gt_n = 1;  // SAR: keep switch
                            zero_force_i = 1;
                            if (DEBUG != 0)
                                $strobe("OFFSAR zero-hit target=%0d dir=%0d step=%0d state=%0d t=%g",
                                    target_idx, direction, sar_step, cal_state, $abstime);
                        end else begin
                            cal_error_i = 1;
                            finish_pending_i = 1;
                        end
                    end
                end

                if (cmp_valid != 0) begin
                    invalid_count = 0;
                    if (zero_force_i == 0) begin
                        cmp_p_gt_n = (V(COMP, DGND) < V(COMN, DGND)) ? 1 : 0;
                        if (CMP_SWAP != 0)
                            cmp_p_gt_n = 1 - cmp_p_gt_n;
                    end
                    zero_force_i = 0;

                    // Comparator-output diagnostic: print S, trial weight, COMP-COMN,
                    // and comparator decision at EVERY SAR step.
                    // COMP-COMN is the regenerated output, not the CDAC top-plate residue.
                    if (DEBUG > 1) begin
                        case (sar_step)
                            0: trial_w = 48;
                            1: trial_w = 32;
                            2: trial_w = 20;
                            3: trial_w = 12;
                            4: trial_w = 8;
                            5: trial_w = 4;
                            6: trial_w = 2;
                            default: trial_w = 0;
                        endcase
                        $strobe("OFFSAR CMPDIAG tgt=%0d dir=%0d st=%0d step=%0d S=%0d trW=%0d S_tr=%0d dmask=%0d umask=%0d CMPd=%gV cmp=%0d t=%g",
                            target_idx, direction, cal_state, sar_step,
                            switched_sum, trial_w, switched_sum + trial_w,
                            d_mask, u_mask, cmp_delta, cmp_p_gt_n, $abstime);
                    end

                    if (cal_state == CAL_SAR_TRIAL) begin
                        // offset-binary SAR decision:
                        // P>N (residual>0) -> KEEP switch
                        // P<N (residual<0) -> UNDO switch
                        if (cmp_p_gt_n != 0) begin
                            // Keep: add trial to switched.
                            switched_mask = switched_mask | trial_mask;
                            // Update switched_sum based on which cap.
                            case (sar_step)
                                0: switched_sum = switched_sum + 48;
                                1: switched_sum = switched_sum + 32;
                                2: switched_sum = switched_sum + 20;
                                3: switched_sum = switched_sum + 12;
                                4: switched_sum = switched_sum + 8;
                                5: switched_sum = switched_sum + 4;
                                6: switched_sum = switched_sum + 2;
                            endcase
                        end
                        // Undo: switched_mask and switched_sum unchanged.

                        sar_step = sar_step + 1;
                        trial_mask = 0;

                        if (sar_step >= 7) begin
                            cal_state = CAL_TERMINAL;
                        end
                    end else if (cal_state == CAL_TERMINAL) begin
                        // Terminal bit: b_T = cmp_p_gt_n
                        code_value = switched_sum + (cmp_p_gt_n != 0 ? 1 : 0);

                        if (direction == 0) begin
                            d_plus_code = code_value;
                            if (DEBUG > 1)
                                $strobe("OFFSAR code target=%0d dir=+ D+=%0d switched=%0d bT=%0d t=%g",
                                    target_idx, d_plus_code, switched_sum,
                                    cmp_p_gt_n, $abstime);
                        end else begin
                            d_minus_code = code_value;
                            if (DEBUG > 1)
                                $strobe("OFFSAR code target=%0d dir=- D-=%0d switched=%0d bT=%0d t=%g",
                                    target_idx, d_minus_code, switched_sum,
                                    cmp_p_gt_n, $abstime);
                        end

                        // V6.2: Saturation detection
                        // calDAC range is 0..127. Codes >=126 or <=1 indicate
                        // the residual was near or beyond the ±126 measurement
                        // range. Flag it so the tolerance check rejects this
                        // measurement instead of silently accepting a clamped
                        // result that passes the ±35% tolerance window.
                        if (code_value >= 126 || code_value <= 1) begin
                            saturate_flag = 1;
                            if (DEBUG != 0)
                                $strobe("OFFSAR SATURATE target=%0d dir=%0d code=%0d (endpoint hit, residual out of range) t=%g",
                                    target_idx, direction, code_value, $abstime);
                        end

                        cal_state = CAL_FINISH_DIR;
                    end
                end
            end
        end

        // RST1 rising (finish direction): compute weight or switch direction.
        @(cross(V(RST1, DGND) - vth, +1)) begin
            if ((cal_mode_i != 0) && (cal_state == CAL_FINISH_DIR)) begin
                if (direction == 0) begin
                    // D+ done, start D-.
                    direction = 1;
                    cal_state = CAL_IDLE;
                end else begin
                    // Both done, compute weight.
                    accum_d_plus = accum_d_plus + d_plus_code;
                    accum_d_minus = accum_d_minus + d_minus_code;
                    repeat_idx = repeat_idx + 1;

                    if (DEBUG > 1)
                        $strobe("OFFSAR pair target=%0d D+=%0d D-=%0d pair=%0d t=%g",
                            target_idx, d_plus_code, d_minus_code, repeat_idx, $abstime);

                    if (repeat_idx >= avg_pairs) begin
                        // Q-format: R_Q = round(q_scale * (sum_D+ - sum_D-) / N)
                        if ((accum_d_plus - accum_d_minus) >= 0)
                            rounding_term = avg_pairs / 2;
                        else
                            rounding_term = -avg_pairs / 2;
                        residual_q = (q_scale * (accum_d_plus - accum_d_minus)
                            + rounding_term) / avg_pairs;

                        measured_weight_q = wall_weight_q + residual_q;

                        if (DEBUG != 0)
                            $strobe("OFFSAR measure target=%0d wall_q=%0d wall=%g D+_sum=%0d D-_sum=%0d R_q=%0d R=%g measured_q=%0d measured=%g t=%g",
                                target_idx, wall_weight_q,
                                1.0*wall_weight_q/q_scale,
                                accum_d_plus, accum_d_minus, residual_q,
                                1.0*residual_q/q_scale, measured_weight_q,
                                1.0*measured_weight_q/q_scale, $abstime);

                        // Calibration registers are always updated so the next
                        // physical wall uses the already measured lower target.
                        // APPLY_CAL_WEIGHT only selects whether these registers
                        // are used by the normal SOUT decoder.
                        case (target_idx)
                            3: begin
                                // w2 (C10, w=512), wall=w3+w4
                                if ((saturate_flag == 0) &&
                                    (measured_weight_q > 512*q_scale*(1-WEIGHT_TOL)) &&
                                    (measured_weight_q < 512*q_scale*(1+WEIGHT_TOL)))
                                    w2 = measured_weight_q;
                                else if (DEBUG != 0)
                                    $strobe("OFFSAR REJECT target=C10 measured_q=%0d measured=%g tol=%g sat=%0d t=%g",
                                        measured_weight_q, 1.0*measured_weight_q/q_scale,
                                        WEIGHT_TOL, saturate_flag, $abstime);
                            end
                            2: begin
                                // w3+w4 joint (C8+C9, w=256+256=512), wall=w2
                                if ((saturate_flag == 0) &&
                                    (measured_weight_q > 512*q_scale*(1-WEIGHT_TOL)) &&
                                    (measured_weight_q < 512*q_scale*(1+WEIGHT_TOL))) begin
                                    w3 = measured_weight_q / 2;
                                    w4 = measured_weight_q / 2;
                                    // V6.2: w2 re-correction.
                                    // w2 was measured with nominal w3+w4 wall:
                                    //   w2_measured = 512 + e2 - E (error: -E)
                                    // This measurement gives true W3+W4 = 512 + E.
                                    // So E = measured - 512, and:
                                    //   w2_corrected = w2 + E = 512 + e2 (exact)
                                    w2 = w2 + (measured_weight_q - 512*q_scale);
                                end else if (DEBUG != 0)
                                    $strobe("OFFSAR REJECT target=C8C9joint measured_q=%0d measured=%g tol=%g sat=%0d t=%g",
                                        measured_weight_q, 1.0*measured_weight_q/q_scale,
                                        WEIGHT_TOL, saturate_flag, $abstime);
                            end
                            1: begin
                                if ((saturate_flag == 0) &&
                                    (measured_weight_q > 1024*q_scale*(1-WEIGHT_TOL)) &&
                                    (measured_weight_q < 1024*q_scale*(1+WEIGHT_TOL)))
                                    w1 = measured_weight_q;
                                else if (DEBUG != 0)
                                    $strobe("OFFSAR REJECT target=C11 measured_q=%0d measured=%g tol=%g sat=%0d t=%g",
                                        measured_weight_q, 1.0*measured_weight_q/q_scale,
                                        WEIGHT_TOL, saturate_flag, $abstime);
                            end
                            0: begin
                                if ((saturate_flag == 0) &&
                                    (measured_weight_q > 2048*q_scale*(1-WEIGHT_TOL)) &&
                                    (measured_weight_q < 2048*q_scale*(1+WEIGHT_TOL)))
                                    w0 = measured_weight_q;
                                else if (DEBUG != 0)
                                    $strobe("OFFSAR REJECT target=C12 measured_q=%0d measured=%g tol=%g sat=%0d t=%g",
                                        measured_weight_q, 1.0*measured_weight_q/q_scale,
                                        WEIGHT_TOL, saturate_flag, $abstime);
                            end
                        endcase

                        target_idx = target_idx - 1;
                        repeat_idx = 0;
                        accum_d_plus = 0;
                        accum_d_minus = 0;
                        saturate_flag = 0;  // reset for next target

                        case (target_idx)
                            2: begin
                                // Next: w3+w4 joint, wall=w2_measured
                                target_mask = 24;       // stages 3,4 joint
                                wall_mask = 4;          // stage 2
                                wall_weight_q = w2;     // just measured
                            end
                            1: begin
                                target_mask = 2;
                                wall_mask = 28;
                                wall_weight_q = w2 + w3 + w4;
                            end
                            0: begin
                                target_mask = 1;
                                wall_mask = 30;
                                wall_weight_q = w1 + w2 + w3 + w4;
                            end
                            default: begin
                                finish_pending_i = 1;
                                target_idx = -1;
                            end
                        endcase
                        direction = 0;
                    end else begin
                        direction = 0;
                    end
                    cal_state = CAL_IDLE;
                end
            end
        end

        // Decode the two clock inputs into piecewise-constant integers.
        // transition() is deliberately kept outside runtime if/else blocks.
        clk_sar_i = (V(CLK_SAR, DGND) > vth) ? 1 : 0;
        clk_cal_i = (V(CAL_CLK, DGND) > vth) ? 1 : 0;

        // Normal decoder: latch one completed RAW conversion only on SOUT.
        // Do NOT decode BP continuously during the 14 SAR decisions; doing so
        // exposes intermediate trial codes on Bit<11:0>.
        @(cross(V(SOUT, DGND) - vth, +1)) begin
            if ((CAL_BYPASS != 0) ||
                ((cal_done_i != 0) && (cal_mode_i == 0))) begin
                // Existing PN-buffer convention: BP[13] is the first/MSB
                // decision and BP[0] is the terminal comparator decision.
                r0  = (V(BP[13], DGND) > vth) ? 1 : 0;
                r1  = (V(BP[12], DGND) > vth) ? 1 : 0;
                r2  = (V(BP[11], DGND) > vth) ? 1 : 0;
                r3  = (V(BP[10], DGND) > vth) ? 1 : 0;
                r4  = (V(BP[9],  DGND) > vth) ? 1 : 0;
                r5  = (V(BP[8],  DGND) > vth) ? 1 : 0;
                r6  = (V(BP[7],  DGND) > vth) ? 1 : 0;
                r7  = (V(BP[6],  DGND) > vth) ? 1 : 0;
                r8  = (V(BP[5],  DGND) > vth) ? 1 : 0;
                r9  = (V(BP[4],  DGND) > vth) ? 1 : 0;
                r10 = (V(BP[3],  DGND) > vth) ? 1 : 0;
                r11 = (V(BP[2],  DGND) > vth) ? 1 : 0;
                r12 = (V(BP[1],  DGND) > vth) ? 1 : 0;
                r13 = (V(BP[0],  DGND) > vth) ? 1 : 0;

                // Preserve the polarity convention of the previously working
                // decoder: RAW_INVERT applies to decisions 1..13; the first/MSB
                // decision has its own FIRST_INVERT control.
                if (RAW_INVERT != 0) begin
                    r1 = 1-r1;   r2 = 1-r2;   r3 = 1-r3;
                    r4 = 1-r4;   r5 = 1-r5;   r6 = 1-r6;
                    r7 = 1-r7;   r8 = 1-r8;   r9 = 1-r9;
                    r10 = 1-r10; r11 = 1-r11; r12 = 1-r12;
                    r13 = 1-r13;
                end
                if (FIRST_INVERT != 0)
                    r0 = 1-r0;

                // Keep calibration estimation separate from normal decoding.
                // w0/w1/w2 always hold the measured recursive calibration
                // registers; APPLY_CAL_WEIGHT selects the normal decoder view.
                if (APPLY_CAL_WEIGHT != 0) begin
                    dec_w0 = w0; dec_w1 = w1; dec_w2 = w2;
                end else begin
                    dec_w0 = 2048*q_scale;
                    dec_w1 = 1024*q_scale;
                    dec_w2 = 512*q_scale;
                end

                raw_sum = r0*dec_w0 + r1*dec_w1 + r2*dec_w2 +
                    r3*w3 + r4*w4 + r5*w5 + r6*w6 + r7*w7 +
                    r8*w8 + r9*w9 + r10*w10 + r11*w11 +
                    r12*w12 + r13*w13;

                total_weight_q = dec_w0 + dec_w1 + dec_w2 +
                    w3 + w4 + w5 + w6 + w7 + w8 + w9 +
                    w10 + w11 + w12 + w13;

                if (NORMALIZE_REDUNDANT_RANGE != 0) begin
                    if (total_weight_q > 0)
                        scaled_code = 4095.0 * raw_sum / total_weight_q;
                    else
                        scaled_code = 0.0;

                    if (scaled_code > 4095.0)
                        adc_code = 4095;
                    else if (scaled_code < 0.0)
                        adc_code = 0;
                    else
                        adc_code = $rtoi(scaled_code + 0.5);
                end else begin
                    if (REMOVE_REDUNDANCY_OFFSET != 0) begin
                        redundancy_offset_q = total_weight_q - 4095*q_scale;
                        // Symmetric nearest-integer division by two.
                        if (redundancy_offset_q >= 0)
                            redundancy_offset_q = (redundancy_offset_q + 1)/2;
                        else
                            redundancy_offset_q = (redundancy_offset_q - 1)/2;
                        centered_sum = raw_sum - redundancy_offset_q;
                    end else begin
                        redundancy_offset_q = 0;
                        centered_sum = raw_sum;
                    end

                    // This is the only Q-to-integer quantization.  Truncating
                    // centered_sum/q_scale would bias calibrated fractional weights.
                    if (centered_sum >= 0)
                        adc_code = (centered_sum + q_scale/2) / q_scale;
                    else
                        adc_code = (centered_sum - q_scale/2) / q_scale;
                end

                clip_low_i = 0;
                clip_high_i = 0;
                if (adc_code < 0) begin
                    adc_code = 0;
                    clip_low_i = 1;
                end else if (adc_code > 4095) begin
                    adc_code = 4095;
                    clip_high_i = 1;
                end

                if ((DEBUG != 0) && (WARN_ON_OUTPUT_CLIP != 0) &&
                    ((clip_low_i != 0) || (clip_high_i != 0)))
                    $strobe("OFFSAR decode clip t=%g raw_q=%0d total_q=%0d center_q=%0d code=%0d low=%0d high=%0d",
                        $abstime, raw_sum, total_weight_q, redundancy_offset_q,
                        adc_code, clip_low_i, clip_high_i);
            end
        end

        // Bit bus is driven from the latched adc_code and therefore remains
        // stable for the entire following conversion frame.
        b0  = (adc_code      ) & 1;
        b1  = (adc_code >>  1) & 1;
        b2  = (adc_code >>  2) & 1;
        b3  = (adc_code >>  3) & 1;
        b4  = (adc_code >>  4) & 1;
        b5  = (adc_code >>  5) & 1;
        b6  = (adc_code >>  6) & 1;
        b7  = (adc_code >>  7) & 1;
        b8  = (adc_code >>  8) & 1;
        b9  = (adc_code >>  9) & 1;
        b10 = (adc_code >> 10) & 1;
        b11 = (adc_code >> 11) & 1;

        // All analog operators are unconditional.  Spectre rejects stateful
        // operators such as transition() inside unrestricted runtime conditionals.
        V(CAL,  DGND) <+ vlogic * transition(cal_mode_i,  TD, TR, TF);
        V(DONE, DGND) <+ vlogic * transition(cal_done_i,  TD, TR, TF);
        V(ERR,  DGND) <+ vlogic * transition(cal_error_i, TD, TR, TF);

        // Final comparator clock uses a finite-R driver.  This removes the
        // rigid voltage branch that can form a loop with an ideal SYNC clock.
        // Single-driver final comparator clock.
        // Normal mode: pass CLK_SAR from SYNC_asnyc.
        // Calibration mode: pass CAL_CLK only while one RST1-low calibration
        // frame is active. This produces exactly 8 comparator edges per
        // direction and keeps comparator dither aligned to a 16-edge D+/D- pair.
        I(CLK, DGND) <+ (V(CLK, DGND) - vlogic * (
            (1 - cal_mode_i) * transition(clk_sar_i, TD, TR, TF) +
            cal_mode_i * transition(frame_active_i * clk_cal_i,
                                    TD_CMP_CAL, TR, TF)))
            / RDRV_CLK;

        V(Bit[0],  DGND) <+ vlogic * transition(b0,  TD, TR, TF);
        V(Bit[1],  DGND) <+ vlogic * transition(b1,  TD, TR, TF);
        V(Bit[2],  DGND) <+ vlogic * transition(b2,  TD, TR, TF);
        V(Bit[3],  DGND) <+ vlogic * transition(b3,  TD, TR, TF);
        V(Bit[4],  DGND) <+ vlogic * transition(b4,  TD, TR, TF);
        V(Bit[5],  DGND) <+ vlogic * transition(b5,  TD, TR, TF);
        V(Bit[6],  DGND) <+ vlogic * transition(b6,  TD, TR, TF);
        V(Bit[7],  DGND) <+ vlogic * transition(b7,  TD, TR, TF);
        V(Bit[8],  DGND) <+ vlogic * transition(b8,  TD, TR, TF);
        V(Bit[9],  DGND) <+ vlogic * transition(b9,  TD, TR, TF);
        V(Bit[10], DGND) <+ vlogic * transition(b10, TD, TR, TF);
        V(Bit[11], DGND) <+ vlogic * transition(b11, TD, TR, TF);

        for (g = 0; g <= 12; g = g + 1) begin
            V(BITD_CAL[g], DGND) <+ vlogic * transition(
                cal_mode_i * ((d_mask >> g) & 1), TD_CAL, TR, TF);
            V(BITU_CAL[g], DGND) <+ vlogic * transition(
                cal_mode_i * ((u_mask >> g) & 1), TD_CAL, TR, TF);
        end
    end
endmodule
