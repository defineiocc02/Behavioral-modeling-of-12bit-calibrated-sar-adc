// Required top-level connectivity for the clean V6 package.
//
// 1) SYNC output terminal named CLK MUST connect to net CLK_SAR:
I100 (CCLK CLK_SAR CLK00 COMN COMP DEC_N DGND DVDD SET<12>) SYNC_asnyc

// 2) Comparator has a new sixth pin CAL:
I102 (CLK COMN COMP N P CAL) COM_ideal

// 3) DEC retains its existing positional interface and is the only CLK driver:
I95 (... CAL_RST CLK_SAR CLK00 CLK
     ... CAL DONE ERR CAL_CLK) DEC_CAL_PHY

// Required ADE variables for calibrated run:
parameters CAL_BYPASS=0 APPLY_CAL_WEIGHT=1

// Clean A/B test:
// A: CAL_BYPASS=0 APPLY_CAL_WEIGHT=0
// B: CAL_BYPASS=0 APPLY_CAL_WEIGHT=1
//
// Pure bypass reference:
// C: CAL_BYPASS=1 APPLY_CAL_WEIGHT=0
