`include "constants.vams"
`include "disciplines.vams"

// ============================================================================
// Differential split-CDAC with Monte-Carlo mismatch on EACH physical Cu cell.
//
// Exact case-sensitive ports:
//   BITU<1:13> : upper/N-side bottom-plate bus
//   BITD<1:13> : lower/P-side bottom-plate bus
//   N, P        : uppercase top-plate/output nodes
//
// Fixed physical topology:
//   LSB unit counts  = 1, 2, 4, 6, 10, 16, 24
//   bridge units     = 1
//   MSB unit counts  = 1, 2, 2, 4, 8, 16
//
// A 16C branch is generated as 16 independent mismatched Cu cells:
//   C16 = Cu_1 + Cu_2 + ... + Cu_16
//
// MISMATCH CONTROL:
//   mc_mode = 0 : ideal
//   mc_mode = 1 : Pelgrom model; change Kc_pair_pct_sqrt_fF
//   mc_mode = 2 : bounded uniform; change uniform_half_range
//   mc_mode = 3 : direct Gaussian unit-cell sigma; change mismatch_pct
//
// For the requested "each physical Cu cell has 1-sigma = 1%" setting:
//   mc_mode      = 3
//   mismatch_pct = 1.0
// ============================================================================

module cdac_split_mc (
    BITU,
    BITD,
    N,
    P
);

    inout [1:13] BITU;
    inout [1:13] BITD;
    inout N, P;

    electrical [1:13] BITU;
    electrical [1:13] BITD;
    electrical N, P;

    electrical p_lsb;
    electrical n_lsb;

    // ------------------------------------------------------------------------
    // Main parameters
    // ------------------------------------------------------------------------

    parameter real Cu = 4f from (0:inf);

    // Default: direct 1-sigma mismatch on each physical unit capacitor.
    parameter integer mc_mode = 3 from [0:3];

    // Mode 3:
    // One physical Cu cell's local Gaussian 1-sigma mismatch, in percent.
    // Example: mismatch_pct=1.0 means sigma(Cu_cell)/Cu = 1%.
    parameter real mismatch_pct = 1.0 from [0:inf);

    // Mode 1:
    // Pair mismatch coefficient in %*sqrt(fF):
    // sigma_pair(DeltaC/C) = Kc/sqrt(C[fF]).
    // The model converts it to one Cu-cell instance sigma by /sqrt(2).
    parameter real Kc_pair_pct_sqrt_fF = 0.14 from [0:inf);

    // Gaussian clipping limit.
    parameter real clip_sigma = 3.0 from (0:inf);

    // Mode 2:
    // Relative half-range for EACH Cu cell.
    // Example: 0.01 means every Cu cell is uniform in [-1%, +1%].
    parameter real uniform_half_range = 1.0e-3 from [0:1);

    // Shared global 1-sigma relative variation.
    // Example: 0.01 means 1% common-mode sigma.
    parameter real sigma_global_rel = 0.0 from [0:1);

    // Seed controls.
    parameter integer base_seed   = 13579;
    parameter integer run_id      = 0;
    parameter integer instance_id = 0;

    // Optional top-plate parasitics.
    parameter real Ctop_P = 0.0 from [0:inf);
    parameter real Ctop_N = 0.0 from [0:inf);

    parameter integer print_caps = 1 from [0:1];
    parameter real Cmin_ratio = 1.0e-6 from (0:1);

    // ------------------------------------------------------------------------
    // Realized branch capacitances
    // ------------------------------------------------------------------------

    real cp1, cp2, cp3, cp4, cp5, cp6, cp7;
    real cp8, cp9, cp10, cp11, cp12, cp13;
    real cn1, cn2, cn3, cn4, cn5, cn6, cn7;
    real cn8, cn9, cn10, cn11, cn12, cn13;
    real cbp, cbn;

    integer seed;
    integer trial;
    integer k;
    real z;
    real g_common;

    analog function real clip_value;
        input x, lo, hi;
        real x, lo, hi;
        begin
            if (x > hi)
                clip_value = hi;
            else if (x < lo)
                clip_value = lo;
            else
                clip_value = x;
        end
    endfunction

    // Realize ONE physical Cu cell.
    analog function real realize_one_unit;
        input z_local, global_rel;
        real z_local, global_rel;
        real sigma_rel;
        real local_rel;
        real c_tmp;
        begin
            if (mc_mode == 0) begin
                local_rel = 0.0;
            end
            else if (mc_mode == 1) begin
                sigma_rel =
                    (Kc_pair_pct_sqrt_fF * 0.01) /
                    (sqrt(Cu/1f) * sqrt(2.0));

                local_rel =
                    sigma_rel *
                    clip_value(z_local, -clip_sigma, clip_sigma);
            end
            else if (mc_mode == 2) begin
                local_rel =
                    uniform_half_range *
                    clip_value(z_local, -1.0, 1.0);
            end
            else begin
                sigma_rel = mismatch_pct * 0.01;

                local_rel =
                    sigma_rel *
                    clip_value(z_local, -clip_sigma, clip_sigma);
            end

            c_tmp = Cu * (1.0 + global_rel + local_rel);

            if (c_tmp < Cu*Cmin_ratio)
                realize_one_unit = Cu*Cmin_ratio;
            else
                realize_one_unit = c_tmp;
        end
    endfunction

    analog begin

        @(initial_step) begin
            trial = $cds_get_mc_trial_number();
            if (trial < 0)
                trial = 0;

            seed =
                base_seed
                + 104729*(trial + 1)
                + 1009*run_id
                + 7919*instance_id;

            if ((mc_mode != 0) && (sigma_global_rel > 0.0)) begin
                z = $rdist_normal(seed, 0.0, 1.0, "instance");
                g_common =
                    sigma_global_rel *
                    clip_value(z, -clip_sigma, clip_sigma);
            end
            else begin
                g_common = 0.0;
            end

            // ------------------------ P/lower side ------------------------
            cp1 = 0.0;
            for (k = 0; k < 1; k = k + 1) begin
                if (mc_mode == 0)
                    z = 0.0;
                else if (mc_mode == 2)
                    z = $rdist_uniform(seed, -1.0, 1.0, "instance");
                else
                    z = $rdist_normal(seed, 0.0, 1.0, "instance");

                cp1 = cp1 + realize_one_unit(z, g_common);
            end

            cp2 = 0.0;
            for (k = 0; k < 2; k = k + 1) begin
                if (mc_mode == 0)
                    z = 0.0;
                else if (mc_mode == 2)
                    z = $rdist_uniform(seed, -1.0, 1.0, "instance");
                else
                    z = $rdist_normal(seed, 0.0, 1.0, "instance");

                cp2 = cp2 + realize_one_unit(z, g_common);
            end

            cp3 = 0.0;
            for (k = 0; k < 4; k = k + 1) begin
                if (mc_mode == 0)
                    z = 0.0;
                else if (mc_mode == 2)
                    z = $rdist_uniform(seed, -1.0, 1.0, "instance");
                else
                    z = $rdist_normal(seed, 0.0, 1.0, "instance");

                cp3 = cp3 + realize_one_unit(z, g_common);
            end

            cp4 = 0.0;
            for (k = 0; k < 6; k = k + 1) begin
                if (mc_mode == 0)
                    z = 0.0;
                else if (mc_mode == 2)
                    z = $rdist_uniform(seed, -1.0, 1.0, "instance");
                else
                    z = $rdist_normal(seed, 0.0, 1.0, "instance");

                cp4 = cp4 + realize_one_unit(z, g_common);
            end

            cp5 = 0.0;
            for (k = 0; k < 10; k = k + 1) begin
                if (mc_mode == 0)
                    z = 0.0;
                else if (mc_mode == 2)
                    z = $rdist_uniform(seed, -1.0, 1.0, "instance");
                else
                    z = $rdist_normal(seed, 0.0, 1.0, "instance");

                cp5 = cp5 + realize_one_unit(z, g_common);
            end

            cp6 = 0.0;
            for (k = 0; k < 16; k = k + 1) begin
                if (mc_mode == 0)
                    z = 0.0;
                else if (mc_mode == 2)
                    z = $rdist_uniform(seed, -1.0, 1.0, "instance");
                else
                    z = $rdist_normal(seed, 0.0, 1.0, "instance");

                cp6 = cp6 + realize_one_unit(z, g_common);
            end

            cp7 = 0.0;
            for (k = 0; k < 24; k = k + 1) begin
                if (mc_mode == 0)
                    z = 0.0;
                else if (mc_mode == 2)
                    z = $rdist_uniform(seed, -1.0, 1.0, "instance");
                else
                    z = $rdist_normal(seed, 0.0, 1.0, "instance");

                cp7 = cp7 + realize_one_unit(z, g_common);
            end

            cbp = 0.0;
            for (k = 0; k < 1; k = k + 1) begin
                if (mc_mode == 0)
                    z = 0.0;
                else if (mc_mode == 2)
                    z = $rdist_uniform(seed, -1.0, 1.0, "instance");
                else
                    z = $rdist_normal(seed, 0.0, 1.0, "instance");

                cbp = cbp + realize_one_unit(z, g_common);
            end

            cp8 = 0.0;
            for (k = 0; k < 1; k = k + 1) begin
                if (mc_mode == 0)
                    z = 0.0;
                else if (mc_mode == 2)
                    z = $rdist_uniform(seed, -1.0, 1.0, "instance");
                else
                    z = $rdist_normal(seed, 0.0, 1.0, "instance");

                cp8 = cp8 + realize_one_unit(z, g_common);
            end

            cp9 = 0.0;
            for (k = 0; k < 2; k = k + 1) begin
                if (mc_mode == 0)
                    z = 0.0;
                else if (mc_mode == 2)
                    z = $rdist_uniform(seed, -1.0, 1.0, "instance");
                else
                    z = $rdist_normal(seed, 0.0, 1.0, "instance");

                cp9 = cp9 + realize_one_unit(z, g_common);
            end

            cp10 = 0.0;
            for (k = 0; k < 2; k = k + 1) begin
                if (mc_mode == 0)
                    z = 0.0;
                else if (mc_mode == 2)
                    z = $rdist_uniform(seed, -1.0, 1.0, "instance");
                else
                    z = $rdist_normal(seed, 0.0, 1.0, "instance");

                cp10 = cp10 + realize_one_unit(z, g_common);
            end

            cp11 = 0.0;
            for (k = 0; k < 4; k = k + 1) begin
                if (mc_mode == 0)
                    z = 0.0;
                else if (mc_mode == 2)
                    z = $rdist_uniform(seed, -1.0, 1.0, "instance");
                else
                    z = $rdist_normal(seed, 0.0, 1.0, "instance");

                cp11 = cp11 + realize_one_unit(z, g_common);
            end

            cp12 = 0.0;
            for (k = 0; k < 8; k = k + 1) begin
                if (mc_mode == 0)
                    z = 0.0;
                else if (mc_mode == 2)
                    z = $rdist_uniform(seed, -1.0, 1.0, "instance");
                else
                    z = $rdist_normal(seed, 0.0, 1.0, "instance");

                cp12 = cp12 + realize_one_unit(z, g_common);
            end

            cp13 = 0.0;
            for (k = 0; k < 16; k = k + 1) begin
                if (mc_mode == 0)
                    z = 0.0;
                else if (mc_mode == 2)
                    z = $rdist_uniform(seed, -1.0, 1.0, "instance");
                else
                    z = $rdist_normal(seed, 0.0, 1.0, "instance");

                cp13 = cp13 + realize_one_unit(z, g_common);
            end

            // ------------------------ N/upper side ------------------------
            cn1 = 0.0;
            for (k = 0; k < 1; k = k + 1) begin
                if (mc_mode == 0)
                    z = 0.0;
                else if (mc_mode == 2)
                    z = $rdist_uniform(seed, -1.0, 1.0, "instance");
                else
                    z = $rdist_normal(seed, 0.0, 1.0, "instance");

                cn1 = cn1 + realize_one_unit(z, g_common);
            end

            cn2 = 0.0;
            for (k = 0; k < 2; k = k + 1) begin
                if (mc_mode == 0)
                    z = 0.0;
                else if (mc_mode == 2)
                    z = $rdist_uniform(seed, -1.0, 1.0, "instance");
                else
                    z = $rdist_normal(seed, 0.0, 1.0, "instance");

                cn2 = cn2 + realize_one_unit(z, g_common);
            end

            cn3 = 0.0;
            for (k = 0; k < 4; k = k + 1) begin
                if (mc_mode == 0)
                    z = 0.0;
                else if (mc_mode == 2)
                    z = $rdist_uniform(seed, -1.0, 1.0, "instance");
                else
                    z = $rdist_normal(seed, 0.0, 1.0, "instance");

                cn3 = cn3 + realize_one_unit(z, g_common);
            end

            cn4 = 0.0;
            for (k = 0; k < 6; k = k + 1) begin
                if (mc_mode == 0)
                    z = 0.0;
                else if (mc_mode == 2)
                    z = $rdist_uniform(seed, -1.0, 1.0, "instance");
                else
                    z = $rdist_normal(seed, 0.0, 1.0, "instance");

                cn4 = cn4 + realize_one_unit(z, g_common);
            end

            cn5 = 0.0;
            for (k = 0; k < 10; k = k + 1) begin
                if (mc_mode == 0)
                    z = 0.0;
                else if (mc_mode == 2)
                    z = $rdist_uniform(seed, -1.0, 1.0, "instance");
                else
                    z = $rdist_normal(seed, 0.0, 1.0, "instance");

                cn5 = cn5 + realize_one_unit(z, g_common);
            end

            cn6 = 0.0;
            for (k = 0; k < 16; k = k + 1) begin
                if (mc_mode == 0)
                    z = 0.0;
                else if (mc_mode == 2)
                    z = $rdist_uniform(seed, -1.0, 1.0, "instance");
                else
                    z = $rdist_normal(seed, 0.0, 1.0, "instance");

                cn6 = cn6 + realize_one_unit(z, g_common);
            end

            cn7 = 0.0;
            for (k = 0; k < 24; k = k + 1) begin
                if (mc_mode == 0)
                    z = 0.0;
                else if (mc_mode == 2)
                    z = $rdist_uniform(seed, -1.0, 1.0, "instance");
                else
                    z = $rdist_normal(seed, 0.0, 1.0, "instance");

                cn7 = cn7 + realize_one_unit(z, g_common);
            end

            cbn = 0.0;
            for (k = 0; k < 1; k = k + 1) begin
                if (mc_mode == 0)
                    z = 0.0;
                else if (mc_mode == 2)
                    z = $rdist_uniform(seed, -1.0, 1.0, "instance");
                else
                    z = $rdist_normal(seed, 0.0, 1.0, "instance");

                cbn = cbn + realize_one_unit(z, g_common);
            end

            cn8 = 0.0;
            for (k = 0; k < 1; k = k + 1) begin
                if (mc_mode == 0)
                    z = 0.0;
                else if (mc_mode == 2)
                    z = $rdist_uniform(seed, -1.0, 1.0, "instance");
                else
                    z = $rdist_normal(seed, 0.0, 1.0, "instance");

                cn8 = cn8 + realize_one_unit(z, g_common);
            end

            cn9 = 0.0;
            for (k = 0; k < 2; k = k + 1) begin
                if (mc_mode == 0)
                    z = 0.0;
                else if (mc_mode == 2)
                    z = $rdist_uniform(seed, -1.0, 1.0, "instance");
                else
                    z = $rdist_normal(seed, 0.0, 1.0, "instance");

                cn9 = cn9 + realize_one_unit(z, g_common);
            end

            cn10 = 0.0;
            for (k = 0; k < 2; k = k + 1) begin
                if (mc_mode == 0)
                    z = 0.0;
                else if (mc_mode == 2)
                    z = $rdist_uniform(seed, -1.0, 1.0, "instance");
                else
                    z = $rdist_normal(seed, 0.0, 1.0, "instance");

                cn10 = cn10 + realize_one_unit(z, g_common);
            end

            cn11 = 0.0;
            for (k = 0; k < 4; k = k + 1) begin
                if (mc_mode == 0)
                    z = 0.0;
                else if (mc_mode == 2)
                    z = $rdist_uniform(seed, -1.0, 1.0, "instance");
                else
                    z = $rdist_normal(seed, 0.0, 1.0, "instance");

                cn11 = cn11 + realize_one_unit(z, g_common);
            end

            cn12 = 0.0;
            for (k = 0; k < 8; k = k + 1) begin
                if (mc_mode == 0)
                    z = 0.0;
                else if (mc_mode == 2)
                    z = $rdist_uniform(seed, -1.0, 1.0, "instance");
                else
                    z = $rdist_normal(seed, 0.0, 1.0, "instance");

                cn12 = cn12 + realize_one_unit(z, g_common);
            end

            cn13 = 0.0;
            for (k = 0; k < 16; k = k + 1) begin
                if (mc_mode == 0)
                    z = 0.0;
                else if (mc_mode == 2)
                    z = $rdist_uniform(seed, -1.0, 1.0, "instance");
                else
                    z = $rdist_normal(seed, 0.0, 1.0, "instance");

                cn13 = cn13 + realize_one_unit(z, g_common);
            end

            if (print_caps != 0) begin
                $strobe(
                    "%M trial=%0d run_id=%0d mc_mode=%0d Cu=%g mismatch_pct=%g Kc=%g uniform_half=%g",
                    trial, run_id, mc_mode, Cu, mismatch_pct,
                    Kc_pair_pct_sqrt_fF, uniform_half_range
                );

                $strobe(
                    "%M P[fF]: C1=%g C2=%g C3=%g C4=%g C5=%g C6=%g C7=%g CB=%g C8=%g C9=%g C10=%g C11=%g C12=%g C13=%g",
                    cp1/1f, cp2/1f, cp3/1f, cp4/1f,
                    cp5/1f, cp6/1f, cp7/1f, cbp/1f,
                    cp8/1f, cp9/1f, cp10/1f, cp11/1f,
                    cp12/1f, cp13/1f
                );

                $strobe(
                    "%M N[fF]: C1=%g C2=%g C3=%g C4=%g C5=%g C6=%g C7=%g CB=%g C8=%g C9=%g C10=%g C11=%g C12=%g C13=%g",
                    cn1/1f, cn2/1f, cn3/1f, cn4/1f,
                    cn5/1f, cn6/1f, cn7/1f, cbn/1f,
                    cn8/1f, cn9/1f, cn10/1f, cn11/1f,
                    cn12/1f, cn13/1f
                );
            end
        end

        // P/lower array: BITD -> P
        I(p_lsb, BITD[1]) <+ cp1  * ddt(V(p_lsb, BITD[1]));
        I(p_lsb, BITD[2]) <+ cp2  * ddt(V(p_lsb, BITD[2]));
        I(p_lsb, BITD[3]) <+ cp3  * ddt(V(p_lsb, BITD[3]));
        I(p_lsb, BITD[4]) <+ cp4  * ddt(V(p_lsb, BITD[4]));
        I(p_lsb, BITD[5]) <+ cp5  * ddt(V(p_lsb, BITD[5]));
        I(p_lsb, BITD[6]) <+ cp6  * ddt(V(p_lsb, BITD[6]));
        I(p_lsb, BITD[7]) <+ cp7  * ddt(V(p_lsb, BITD[7]));

        I(P, p_lsb)       <+ cbp  * ddt(V(P, p_lsb));
        I(P, BITD[8])     <+ cp8  * ddt(V(P, BITD[8]));
        I(P, BITD[9])     <+ cp9  * ddt(V(P, BITD[9]));
        I(P, BITD[10])    <+ cp10 * ddt(V(P, BITD[10]));
        I(P, BITD[11])    <+ cp11 * ddt(V(P, BITD[11]));
        I(P, BITD[12])    <+ cp12 * ddt(V(P, BITD[12]));
        I(P, BITD[13])    <+ cp13 * ddt(V(P, BITD[13]));

        // N/upper array: BITU -> N
        I(n_lsb, BITU[1]) <+ cn1  * ddt(V(n_lsb, BITU[1]));
        I(n_lsb, BITU[2]) <+ cn2  * ddt(V(n_lsb, BITU[2]));
        I(n_lsb, BITU[3]) <+ cn3  * ddt(V(n_lsb, BITU[3]));
        I(n_lsb, BITU[4]) <+ cn4  * ddt(V(n_lsb, BITU[4]));
        I(n_lsb, BITU[5]) <+ cn5  * ddt(V(n_lsb, BITU[5]));
        I(n_lsb, BITU[6]) <+ cn6  * ddt(V(n_lsb, BITU[6]));
        I(n_lsb, BITU[7]) <+ cn7  * ddt(V(n_lsb, BITU[7]));

        I(N, n_lsb)       <+ cbn  * ddt(V(N, n_lsb));
        I(N, BITU[8])     <+ cn8  * ddt(V(N, BITU[8]));
        I(N, BITU[9])     <+ cn9  * ddt(V(N, BITU[9]));
        I(N, BITU[10])    <+ cn10 * ddt(V(N, BITU[10]));
        I(N, BITU[11])    <+ cn11 * ddt(V(N, BITU[11]));
        I(N, BITU[12])    <+ cn12 * ddt(V(N, BITU[12]));
        I(N, BITU[13])    <+ cn13 * ddt(V(N, BITU[13]));

        if (Ctop_P > 0.0)
            I(P) <+ Ctop_P * ddt(V(P));

        if (Ctop_N > 0.0)
            I(N) <+ Ctop_N * ddt(V(N));
    end

endmodule
