// Testbench for Huang Recursive V6 calibration (Binary CDAC)
//
// Tests the full 7-target recursive calibration on a binary CDAC with H=65
// (C_B = 2C integer bridge capacitor).
//
// CDAC TOPOLOGY (all capacitors are strict binary multiples of Cu):
//   Low side  : {1, 2, 4, 8, 16, 32} = 63 Cu   (pure binary, calDAC)
//   Bridge    : 2 Cu                           (integer bridge)
//   High side : {1A, 1R, 2, 4, 8, 16, 32} = 64 Cu  (binary + redundant 1C)
//
// Effective weights (G_B = (63+2)/2 = 32.5, H = 2*32.5 = 65):
//   Low  1C -> 2,   2C -> 4,   4C -> 8,   8C -> 16,  16C -> 32,  32C -> 64
//   High 1C -> 65,  2C -> 130, 4C -> 260, 8C -> 520, 16C -> 1040, 32C -> 2080
//
// This testbench supports:
//   1. Ideal capacitor verification (all caps ideal)
//   2. Single-cap mismatch sweep (parameterized md/mu)
//   3. Normal conversion after calibration (ramp input)
//
// Usage:
//   spectre tb_huang_calibration.scs
//
// Parameters:
//   cunit  - unit capacitance (default 4fF)
//   md8    - D7 High 1C-A mismatch (1.0 = ideal)
//   mu8    - U7 High 1C-A mismatch
//   md9    - D8 High 1C-R mismatch
//   mu9    - U8 High 1C-R mismatch
//   md10   - D9 High 2C mismatch
//   mu10   - U9 High 2C mismatch
//   md11   - D10 High 4C mismatch
//   mu11   - U10 High 4C mismatch
//   md12   - D11 High 8C mismatch
//   mu12   - U11 High 8C mismatch
//   md13   - D12 High 16C mismatch
//   mu13   - U12 High 16C mismatch
//   md14   - D13 High 32C mismatch
//   mu14   - U13 High 32C mismatch

simulator lang=spectre
global 0

ahdl_include "DEC_CAL_PHY_HUANG_V6.va"
ahdl_include "SWITCH_CAL.va"
ahdl_include "CAL_CMP_TB.va"

// Parameters: cunit and per-capacitor mismatch multipliers
// Set all md/mu to 1.0 for ideal; change one to test single-cap mismatch
parameters vdd=1.8 cunit=4f \
    md8=1.0 mu8=1.0 \
    md9=1.0 mu9=1.0 \
    md10=1.0 mu10=1.0 \
    md11=1.0 mu11=1.0 \
    md12=1.0 mu12=1.0 \
    md13=1.0 mu13=1.0 \
    md14=1.0 mu14=1.0

// ==========================================================================
// Power and references
// ==========================================================================
VAGND (AGND 0) vsource dc=0
VDGND (DGND 0) vsource dc=0
VAVDD (AVDD AGND) vsource dc=vdd
VDVDD (DVDD DGND) vsource dc=vdd
VVCM  (VCM AGND) vsource dc=vdd/2
VREFP (VREFP AGND) vsource dc=vdd
VREFN (VREFN AGND) vsource dc=0

// Input signal: DC at VCM for calibration, ramp for normal conversion
VVIP  (VIP AGND) vsource dc=vdd/2
VVIN  (VIN AGND) vsource dc=vdd/2

// ==========================================================================
// Clock and control signals
// ==========================================================================
// RST: sampling reset (100ns period, 14.05ns active)
VRST  (RST AGND) vsource type=pulse val0=0 val1=vdd period=100n \
    delay=100p rise=10p fall=10p width=14.05n

// RST1: top-plate reset / frame control (150ns period, 14n active)
// During calibration, one RST1-low frame = one D+ or D- direction
// 136ns low frame is enough for 13 CAL_CLK pulses at 10ns period
VRST1 (RST1 AGND) vsource type=pulse val0=0 val1=vdd period=150n \
    delay=100p rise=10p fall=10p width=14n

// SOUT: conversion complete strobe
VSOUT (SOUT DGND) vsource type=pulse val0=0 val1=vdd period=100n \
    delay=98n rise=10p fall=10p width=2n

// CLK00: master clock window
VCLK00 (CLK00 DGND) vsource type=pulse val0=0 val1=vdd period=100n \
    delay=20n rise=10p fall=10p width=79n

// CLK_SAR: normal SAR comparison clock (5ns period)
VCLKSAR (CLK_SAR DGND) vsource type=pulse val0=0 val1=vdd period=5n \
    delay=20n rise=10p fall=10p width=2n

// CAL_CLK: calibration SAR clock (10ns period)
// Provides up to 13 pulses per RST1 frame (for high16 target)
// delay=20n so clock starts earlier within RST1-low frame
VCALCLK (CAL_CLK DGND) vsource type=pulse val0=0 val1=vdd period=10n \
    delay=20n rise=10p fall=10p width=5n

// CAL_RST: calibration reset (active low, 75us for full 7-target cal)
// 7 targets × 32 pairs × 2 directions = 448 frames
// Per-target: search_count (6,7,8,9,10,11,12) + 1 terminal = 7,8,9,10,11,12,13 CAL_CLK per direction
// Total CAL_CLK count: 2×32×(7+8+9+10+11+12+13) = 4480 comparisons
// 448 frames × 150ns = 67.2us total; use 75us for margin
VCALRST (CAL_RST DGND) vsource type=pulse val0=vdd val1=0 period=10m \
    delay=50n rise=10p fall=10p width=75u

// ==========================================================================
// Inactive normal-mode controls (during foreground calibration)
// ==========================================================================
VBP0  (BP0  DGND) vsource dc=0
VBP1  (BP1  DGND) vsource dc=0
VBP2  (BP2  DGND) vsource dc=0
VBP3  (BP3  DGND) vsource dc=0
VBP4  (BP4  DGND) vsource dc=0
VBP5  (BP5  DGND) vsource dc=0
VBP6  (BP6  DGND) vsource dc=0
VBP7  (BP7  DGND) vsource dc=0
VBP8  (BP8  DGND) vsource dc=0
VBP9  (BP9  DGND) vsource dc=0
VBP10 (BP10 DGND) vsource dc=0
VBP11 (BP11 DGND) vsource dc=0
VBP12 (BP12 DGND) vsource dc=0
VBP13 (BP13 DGND) vsource dc=0

VSET0  (SET0  DGND) vsource dc=0
VSET1  (SET1  DGND) vsource dc=0
VSET2  (SET2  DGND) vsource dc=0
VSET3  (SET3  DGND) vsource dc=0
VSET4  (SET4  DGND) vsource dc=0
VSET5  (SET5  DGND) vsource dc=0
VSET6  (SET6  DGND) vsource dc=0
VSET7  (SET7  DGND) vsource dc=0
VSET8  (SET8  DGND) vsource dc=0
VSET9  (SET9  DGND) vsource dc=0
VSET10 (SET10 DGND) vsource dc=0
VSET11 (SET11 DGND) vsource dc=0
VSET12 (SET12 DGND) vsource dc=0

VBN0  (BN0  DGND) vsource dc=0
VBN1  (BN1  DGND) vsource dc=0
VBN2  (BN2  DGND) vsource dc=0
VBN3  (BN3  DGND) vsource dc=0
VBN4  (BN4  DGND) vsource dc=0
VBN5  (BN5  DGND) vsource dc=0
VBN6  (BN6  DGND) vsource dc=0
VBN7  (BN7  DGND) vsource dc=0
VBN8  (BN8  DGND) vsource dc=0
VBN9  (BN9  DGND) vsource dc=0
VBN10 (BN10 DGND) vsource dc=0
VBN11 (BN11 DGND) vsource dc=0
VBN12 (BN12 DGND) vsource dc=0
VBN13 (BN13 DGND) vsource dc=0

VBPX0  (BPX0  DGND) vsource dc=0
VBPX1  (BPX1  DGND) vsource dc=0
VBPX2  (BPX2  DGND) vsource dc=0
VBPX3  (BPX3  DGND) vsource dc=0
VBPX4  (BPX4  DGND) vsource dc=0
VBPX5  (BPX5  DGND) vsource dc=0
VBPX6  (BPX6  DGND) vsource dc=0
VBPX7  (BPX7  DGND) vsource dc=0
VBPX8  (BPX8  DGND) vsource dc=0
VBPX9  (BPX9  DGND) vsource dc=0
VBPX10 (BPX10 DGND) vsource dc=0
VBPX11 (BPX11 DGND) vsource dc=0
VBPX12 (BPX12 DGND) vsource dc=0
VBPX13 (BPX13 DGND) vsource dc=0

// DITHER_IDX[4:0] is an OUTPUT from DEC_CAL_PHY — nets only (no vsource)

// ==========================================================================
// DEC_CAL_PHY (Huang V6 - 7-target recursive calibration, binary CDAC)
// ==========================================================================
XDEC (B11 B10 B9 B8 B7 B6 B5 B4 B3 B2 B1 B0 \
    BP0 BP1 BP2 BP3 BP4 BP5 BP6 BP7 BP8 BP9 BP10 BP11 BP12 BP13 \
    DGND DVDD SOUT COMP COMN RST1 CAL_RST CLK_SAR CLK00 CLK \
    DC0 DC1 DC2 DC3 DC4 DC5 DC6 DC7 DC8 DC9 DC10 DC11 DC12 \
    UC0 UC1 UC2 UC3 UC4 UC5 UC6 UC7 UC8 UC9 UC10 UC11 UC12 \
    CAL DONE ERR CAL_CLK DITH4 DITH3 DITH2 DITH1 DITH0) DEC_CAL_PHY \
    DEBUG=2 CMP_SWAP=0 NOM_H1_WEIGHT=65 \
    FRAC_BITS=6 AVG_PAIRS_LOG2=5 \
    WEIGHT_TOL=0.20 MIN_CAL_HEADROOM_LSB=2.0 \
    FAIL_ON_ENDPOINT=0 CAL_BYPASS=0 APPLY_CAL_WEIGHT=1 \
    REVERT_ON_ERROR=1 REMOVE_REDUNDANCY_OFFSET=1

// ==========================================================================
// SWITCH_CAL (unchanged)
// ==========================================================================
XSW (AGND AVDD \
    D1 D2 D3 D4 D5 D6 D7 D8 D9 D10 D11 D12 D13 \
    BN0 BN1 BN2 BN3 BN4 BN5 BN6 BN7 BN8 BN9 BN10 BN11 BN12 BN13 \
    BPX0 BPX1 BPX2 BPX3 BPX4 BPX5 BPX6 BPX7 BPX8 BPX9 BPX10 BPX11 BPX12 BPX13 \
    U1 U2 U3 U4 U5 U6 U7 U8 U9 U10 U11 U12 U13 \
    N P RST RST1 \
    SET0 SET1 SET2 SET3 SET4 SET5 SET6 SET7 SET8 SET9 SET10 SET11 SET12 \
    VCM VIN VIP VREFN VREFP \
    DC0 DC1 DC2 DC3 DC4 DC5 DC6 DC7 DC8 DC9 DC10 DC11 DC12 \
    UC0 UC1 UC2 UC3 UC4 UC5 UC6 UC7 UC8 UC9 UC10 UC11 UC12 \
    CAL CAL_CLK) SWITCH_CAL

// ==========================================================================
// Comparator model (testbench version)
// ==========================================================================
XCMP (P N CLK RST COMP COMN DGND DVDD) CAL_CMP_TB

// ==========================================================================
// Physical CDAC with H=65 (C_B = 2C integer bridge)
//
// CDAC TOPOLOGY (all capacitors are strict binary multiples of Cu):
//   Low side  : {1, 2, 4, 8, 16, 32} = 63 Cu   (pure binary, calDAC)
//   Bridge    : 2 Cu                           (integer bridge)
//   High side : {1A, 1R, 2, 4, 8, 16, 32} = 64 Cu  (binary + redundant 1C)
//
// Effective weights (G_B = (63+2)/2 = 32.5, H = 2*32.5 = 65):
//   Low  1C -> 2,   2C -> 4,   4C -> 8,   8C -> 16,  16C -> 32,  32C -> 64
//   High 1C -> 65,  2C -> 130, 4C -> 260, 8C -> 520, 16C -> 1040, 32C -> 2080
//
// Capacitor index mapping (SWITCH_CAL: BITD_CAL[g] → D(13-g) per its loop):
//   D1..D6    = low 1C..32C    (stages 12..7, calDAC)
//   BR (PD-P) = bridge 2C
//   D7        = high 1C-A      (stage 6, weight 65,   cal target 0)
//   D8        = high 1C-R      (stage 5, weight 65,   cal target 1, redundant)
//   D9        = high 2C        (stage 4, weight 130,  cal target 2)
//   D10       = high 4C        (stage 3, weight 260,  cal target 3)
//   D11       = high 8C        (stage 2, weight 520,  cal target 4)
//   D12       = high 16C       (stage 1, weight 1040, cal target 5)
//   D13       = high 32C       (stage 0, weight 2080, cal target 6)
// ==========================================================================

// P-side low segment (behind bridge, binary: 1,2,4,8,16,32 = 63Cu)
CD1  (D1  PD) capacitor c=1*cunit
CD2  (D2  PD) capacitor c=2*cunit
CD3  (D3  PD) capacitor c=4*cunit
CD4  (D4  PD) capacitor c=8*cunit
CD5  (D5  PD) capacitor c=16*cunit
CD6  (D6  PD) capacitor c=32*cunit

// P-side bridge (integer 2C for H=65)
CDBR (PD  P)  capacitor c=2*cunit

// P-side high segment (direct to top plate, SWITCH_CAL mapping: BITD_CAL[g]→D(13-g))
CD7  (D7  P)  capacitor c=md8*1*cunit    // High 1C-A (stage 6, weight 65)   BITD_CAL[6]→D7
CD8  (D8  P)  capacitor c=md9*1*cunit    // High 1C-R (stage 5, weight 65)   BITD_CAL[5]→D8
CD9  (D9  P)  capacitor c=md10*2*cunit   // High 2C   (stage 4, weight 130)  BITD_CAL[4]→D9
CD10 (D10 P)  capacitor c=md11*4*cunit   // High 4C   (stage 3, weight 260)  BITD_CAL[3]→D10
CD11 (D11 P)  capacitor c=md12*8*cunit   // High 8C   (stage 2, weight 520)  BITD_CAL[2]→D11
CD12 (D12 P)  capacitor c=md13*16*cunit  // High 16C  (stage 1, weight 1040) BITD_CAL[1]→D12
CD13 (D13 P)  capacitor c=md14*32*cunit  // High 32C  (stage 0, weight 2080) BITD_CAL[0]→D13

// N-side low segment — differential counterpart (binary: 1,2,4,8,16,32 = 63Cu)
CU1  (U1  PU) capacitor c=1*cunit
CU2  (U2  PU) capacitor c=2*cunit
CU3  (U3  PU) capacitor c=4*cunit
CU4  (U4  PU) capacitor c=8*cunit
CU5  (U5  PU) capacitor c=16*cunit
CU6  (U6  PU) capacitor c=32*cunit

// N-side bridge (integer 2C)
CUBR (PU  N)  capacitor c=2*cunit

// N-side high segment (mirror, SWITCH_CAL: BITU_CAL[g]→U(13-g))
CU7  (U7  N)  capacitor c=mu8*1*cunit    // High 1C-A (stage 6)
CU8  (U8  N)  capacitor c=mu9*1*cunit    // High 1C-R (stage 5)
CU9  (U9  N)  capacitor c=mu10*2*cunit   // High 2C   (stage 4)
CU10 (U10 N)  capacitor c=mu11*4*cunit   // High 4C   (stage 3)
CU11 (U11 N)  capacitor c=mu12*8*cunit   // High 8C   (stage 2)
CU12 (U12 N)  capacitor c=mu13*16*cunit  // High 16C  (stage 1)
CU13 (U13 N)  capacitor c=mu14*32*cunit  // High 32C  (stage 0)

// Top-plate parasitics
CPP (P AGND) capacitor c=5f
CPN (N AGND) capacitor c=5f

// ==========================================================================
// Simulation
// ==========================================================================
// Full 7-target calibration:
//   7 targets × 32 pairs × 2 directions = 448 frames
//   Per-target: search_count (6,7,8,9,10,11,12) + 1 terminal = 7,8,9,10,11,12,13 CAL_CLK per direction
//   Total CAL_CLK count: 2×32×(7+8+9+10+11+12+13) = 4480 comparisons
//   448 frames × 150ns = 67.2us total; use 85us for margin + normal conversions
tran tran stop=85u maxstep=500p method=gear2only \
    reltol=1e-4 vabstol=1e-9 iabstol=1e-12

save CAL DONE ERR CLK CAL_CLK COMP COMN P N PD PU \
    DC0 DC1 DC2 DC3 DC4 DC5 DC6 DC7 DC8 DC9 DC10 DC11 DC12 \
    UC0 UC1 UC2 UC3 UC4 UC5 UC6 UC7 UC8 UC9 UC10 UC11 UC12 \
    B0 B1 B2 B3 B4 B5 B6 B7 B8 B9 B10 B11
saveOptions options save=selected
