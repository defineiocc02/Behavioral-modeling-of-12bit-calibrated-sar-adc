// Clean V6 deterministic normal-SAR timing replacement for SYNC_asnyc.
// Exact positional interface of the existing cell:
//   SYNC_asnyc CCLK CLK CLK00 COMN COMP DEC_N DGND DVDD SET<12>
//
// IMPORTANT TOP-LEVEL CONNECTION:
//   The symbol terminal named CLK must be connected to net CLK_SAR.
//   DEC_CAL_PHY alone drives the final comparator net CLK.
//
// The final scalar pin remains connected to SET<12> for interface compatibility.
//
// A CLK00 rising edge starts exactly 14 comparator/SAR cycles:
//   phase 0: CLK rises       -> comparator captures P/N
//   phase 1: CLK falls       -> comparator output remains latched
//   phase 2: CCLK rises      -> SAR logic stores COMN and applies next trial
//   phase 3: CCLK falls
// Default timing: 4 ns per decision, 56 ns total for 14 decisions.

`include "constants.vams"
`include "disciplines.vams"

module SYNC_asnyc (
    CCLK, CLK, CLK00, COMN, COMP, DEC_N, DGND, DVDD, SET
);
    output CCLK, CLK;
    input CLK00, COMN, COMP;
    output DEC_N;
    inout DGND, DVDD;
    input [12:12] SET;

    electrical CCLK, CLK, CLK00, COMN, COMP, DEC_N, DGND, DVDD;
    electrical [12:12] SET;

    parameter real VTH_FRACTION = 0.5 from (0.0:1.0);
    parameter real TPHASE = 1n from (0.0:inf);
    parameter integer NDEC = 14 from [1:32];
    parameter real TD = 20p from [0.0:inf);
    parameter real TR = 10p from (0.0:inf);
    parameter real TF = 10p from (0.0:inf);
    parameter real RDRV = 1.0 from (0.0:inf);

    integer run_i;
    integer phase_i;
    integer cycle_i;
    integer clk_i;
    integer cclk_i;
    integer dec_n_i;
    real next_phase_time;

    real vlogic;
    real vth;

    analog begin
        vlogic = V(DVDD, DGND);
        vth = VTH_FRACTION * vlogic;
        dec_n_i = (V(COMN, DGND) > vth) ? 1 : 0;

        @(initial_step) begin
            run_i = 0;
            phase_i = 0;
            cycle_i = 0;
            clk_i = 0;
            cclk_i = 0;
            next_phase_time = 0.0;
        end

        // Start one complete 14-decision conversion window.
        // Schedule first timer event relative to CLK00 rising edge.
        @(cross(V(CLK00, DGND) - vth, +1)) begin
            run_i = 1;
            phase_i = 0;
            cycle_i = 0;
            clk_i = 0;
            cclk_i = 0;
            next_phase_time = $abstime + TPHASE;
        end

        // Hard stop at the end of the externally supplied conversion window.
        @(cross(V(CLK00, DGND) - vth, -1)) begin
            run_i = 0;
            clk_i = 0;
            cclk_i = 0;
        end

        // Clock-edge scheduler, triggered by next_phase_time.
        // Only fires when run_i=1 and next_phase_time has been set.
        @(timer(next_phase_time, 0)) begin
            if (run_i != 0) begin
                case (phase_i)
                    0: begin
                        clk_i = 1;
                        cclk_i = 0;
                        phase_i = 1;
                    end
                    1: begin
                        clk_i = 0;
                        cclk_i = 0;
                        phase_i = 2;
                    end
                    2: begin
                        clk_i = 0;
                        cclk_i = 1;
                        phase_i = 3;
                    end
                    default: begin
                        clk_i = 0;
                        cclk_i = 0;
                        if (cycle_i >= (NDEC-1)) begin
                            run_i = 0;
                        end else begin
                            cycle_i = cycle_i + 1;
                            phase_i = 0;
                        end
                    end
                endcase
                // Schedule next phase relative to current time
                next_phase_time = $abstime + TPHASE;
            end
        end

        // Finite-R output drivers: no ideal voltage-source branch is inserted
        // between CLK/CCLK/DEC_N and DGND, eliminating Spectre rigid loops.
        I(CLK, DGND) <+ (V(CLK, DGND) -
            vlogic * transition(clk_i, TD, TR, TF)) / RDRV;
        I(CCLK, DGND) <+ (V(CCLK, DGND) -
            vlogic * transition(cclk_i, TD, TR, TF)) / RDRV;
        I(DEC_N, DGND) <+ (V(DEC_N, DGND) -
            vlogic * transition(dec_n_i, TD, TR, TF)) / RDRV;
    end
endmodule
