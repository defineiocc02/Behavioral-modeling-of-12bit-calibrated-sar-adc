// ============================================================================
// comparator_behavioral.va — StrongArm dynamic comparator behavioural model
//
// Ports:
//   vtop_p, vtop_n  — differential input (from CDAC)
//   clk             — comparator clock (rising edge triggers compare)
//   dout            — digital output (1 = VTOP_P > VTOP_N, 0 otherwise)
//   ready           — ready flag (1 when decision complete)
//   metastable      — metastability flag
//
// Parameters:
//   t0      = base delay (s)
//   tau     = regeneration time constant (s)
//   v_logic = logic swing (V)
//   v_min   = minimum resolvable differential (V)
//   offset  = input offset voltage (V)
//   noise_rms = input-referred noise RMS (V)
//   t_max   = maximum wait time before forced output (s)
// ============================================================================

`include "disciplines.vams"
`include "constants.vams"

module comparator_behavioral(vtop_p, vtop_n, clk, dout, ready, metastable);

  input vtop_p, vtop_n, clk;
  electrical vtop_p, vtop_n, clk;
  output dout, ready, metastable;
  electrical dout, ready, metastable;

  // ── Timing parameters ──
  parameter real t0      = 2.0e-9;   // 2 ns base delay
  parameter real tau     = 0.5e-9;   // 0.5 ns regeneration tau
  parameter real v_logic = 0.9;      // 0.9 V logic swing
  parameter real v_min   = 1.0e-6;   // 1 uV metastability threshold
  parameter real offset  = 0.0;      // input offset (V)
  parameter real noise_rms = 0.0;    // input noise RMS (V)
  parameter real t_max   = 10.0e-9;  // 10 ns timeout

  // ── Internal state ──
  integer seed;
  real    vdiff_eff;
  real    t_decision;
  integer cmp_out;
  integer is_metastable;
  real    clk_prev;
  real    noise_sample;
  real    rnd;

  analog begin
    @(initial_step) begin
      seed = 1;
      cmp_out = 0;
      is_metastable = 0;
      t_decision = t0;
      clk_prev = 0.0;
      noise_sample = 0.0;
    end

    // ── Rising-edge triggered comparison ──
    @(cross(V(clk) - 0.5 * v_logic, +1)) begin

      // Generate noise sample (Box-Muller via uniform random)
      if (noise_rms > 0.0) begin
        // Simple approximation: uniform in [-sqrt(3)*sigma, +sqrt(3)*sigma]
        // with same variance as Gaussian
        rnd = ($random(seed) % 1000000) / 1000000.0;
        rnd = (rnd - 0.5) * 2.0;  // [-1, 1]
        noise_sample = noise_rms * 1.732 * rnd;  // sqrt(3)*sigma
      end else begin
        noise_sample = 0.0;
      end

      // Effective differential input
      vdiff_eff = V(vtop_p) - V(vtop_n) + offset + noise_sample;

      // Decision
      if (abs(vdiff_eff) < v_min) begin
        is_metastable = 1;
        cmp_out = 0;  // arbitrary
        t_decision = t_max;
      end else begin
        is_metastable = 0;
        if (vdiff_eff > 0.0)
          cmp_out = 1;
        else
          cmp_out = 0;

        // t_decision = t0 + tau * ln(v_logic / |vdiff_eff|)
        t_decision = t0 + tau * ln(v_logic / abs(vdiff_eff));
        if (t_decision > t_max)
          t_decision = t_max;
      end
    end

    // ── Output drivers ──
    if (cmp_out == 1)
      V(dout) <+ v_logic;
    else
      V(dout) <+ 0.0;

    if ($abstime > t_decision)
      V(ready) <+ v_logic;
    else
      V(ready) <+ 0.0;

    if (is_metastable == 1)
      V(metastable) <+ v_logic;
    else
      V(metastable) <+ 0.0;

    clk_prev = V(clk);
  end

endmodule
