// cdac_behavioral.va — differential split-CDAC charge-conservation model
//
// The P and N arrays have independent bottom-plate ports and independent
// mismatch parameters.  SAMPLE high clamps only VTOP to VCM; VBRIDGE remains
// the internal floating split-array node and assumes its capacitive-divider
// voltage.  The falling SAMPLE edge captures both node charges from VINP/VINN
// on all 14 physical capacitors.  Subsequent bottom-plate rail changes are
// solved by the exact two-node charge-conservation matrix on each side.

`include "constants.vams"
`include "disciplines.vams"

module cdac_behavioral(
  vtop_p, vtop_n, vbridge_p, vbridge_n,
  vinp, vinn, sample,
  vbot_p_h0, vbot_p_h1, vbot_p_h2, vbot_p_h3,
  vbot_p_h4, vbot_p_h5, vbot_p_h6,
  vbot_p_l0, vbot_p_l1, vbot_p_l2, vbot_p_l3,
  vbot_p_l4, vbot_p_l5, vbot_p_l6,
  vbot_n_h0, vbot_n_h1, vbot_n_h2, vbot_n_h3,
  vbot_n_h4, vbot_n_h5, vbot_n_h6,
  vbot_n_l0, vbot_n_l1, vbot_n_l2, vbot_n_l3,
  vbot_n_l4, vbot_n_l5, vbot_n_l6
);
  output vtop_p, vtop_n, vbridge_p, vbridge_n;
  input vinp, vinn, sample;
  input vbot_p_h0, vbot_p_h1, vbot_p_h2, vbot_p_h3;
  input vbot_p_h4, vbot_p_h5, vbot_p_h6;
  input vbot_p_l0, vbot_p_l1, vbot_p_l2, vbot_p_l3;
  input vbot_p_l4, vbot_p_l5, vbot_p_l6;
  input vbot_n_h0, vbot_n_h1, vbot_n_h2, vbot_n_h3;
  input vbot_n_h4, vbot_n_h5, vbot_n_h6;
  input vbot_n_l0, vbot_n_l1, vbot_n_l2, vbot_n_l3;
  input vbot_n_l4, vbot_n_l5, vbot_n_l6;
  electrical vtop_p, vtop_n, vbridge_p, vbridge_n;
  electrical vinp, vinn, sample;
  electrical vbot_p_h0, vbot_p_h1, vbot_p_h2, vbot_p_h3;
  electrical vbot_p_h4, vbot_p_h5, vbot_p_h6;
  electrical vbot_p_l0, vbot_p_l1, vbot_p_l2, vbot_p_l3;
  electrical vbot_p_l4, vbot_p_l5, vbot_p_l6;
  electrical vbot_n_h0, vbot_n_h1, vbot_n_h2, vbot_n_h3;
  electrical vbot_n_h4, vbot_n_h5, vbot_n_h6;
  electrical vbot_n_l0, vbot_n_l1, vbot_n_l2, vbot_n_l3;
  electrical vbot_n_l4, vbot_n_l5, vbot_n_l6;

  parameter real CU = 4.0e-15 from (0:inf);
  parameter real VCM_V = 0.9;
  parameter real SAMPLE_THRESHOLD_V = 0.45;
  parameter real TR_S = 1.0e-12 from [0:inf);

  parameter real P_MC_H0=1.0, P_MC_H1=1.0, P_MC_H2=1.0;
  parameter real P_MC_H3=1.0, P_MC_H4=1.0, P_MC_H5=1.0;
  parameter real P_MC_H6=1.0, P_MC_B=1.0;
  parameter real P_MC_L0=1.0, P_MC_L1=1.0, P_MC_L2=1.0;
  parameter real P_MC_L3=1.0, P_MC_L4=1.0, P_MC_L5=1.0;
  parameter real P_MC_L6=1.0;
  parameter real N_MC_H0=1.0, N_MC_H1=1.0, N_MC_H2=1.0;
  parameter real N_MC_H3=1.0, N_MC_H4=1.0, N_MC_H5=1.0;
  parameter real N_MC_H6=1.0, N_MC_B=1.0;
  parameter real N_MC_L0=1.0, N_MC_L1=1.0, N_MC_L2=1.0;
  parameter real N_MC_L3=1.0, N_MC_L4=1.0, N_MC_L5=1.0;
  parameter real N_MC_L6=1.0;

  real p_h0,p_h1,p_h2,p_h3,p_h4,p_h5,p_h6,p_b;
  real p_l0,p_l1,p_l2,p_l3,p_l4,p_l5,p_l6;
  real n_h0,n_h1,n_h2,n_h3,n_h4,n_h5,n_h6,n_b;
  real n_l0,n_l1,n_l2,n_l3,n_l4,n_l5,n_l6;
  real p_ht,p_lt,n_ht,n_lt;
  real p_a11,p_a22,p_det,n_a11,n_a22,n_det;
  real p_i11,p_i12,p_i21,p_i22,n_i11,n_i12,n_i21,n_i22;
  real qtp,qbp,qtn,qbn,b1,b2;
  real vtp,vbp,vtn,vbn;
  integer sampled;

  analog begin
    @(initial_step) begin
      p_h0=CU*32*P_MC_H0; p_h1=CU*16*P_MC_H1;
      p_h2=CU*8*P_MC_H2;  p_h3=CU*8*P_MC_H3;
      p_h4=CU*4*P_MC_H4;  p_h5=CU*2*P_MC_H5;
      p_h6=CU*P_MC_H6;    p_b=CU*2*P_MC_B;
      p_l0=CU*32*P_MC_L0; p_l1=CU*16*P_MC_L1;
      p_l2=CU*8*P_MC_L2;  p_l3=CU*4*P_MC_L3;
      p_l4=CU*2*P_MC_L4;  p_l5=CU*2*P_MC_L5;
      p_l6=CU*P_MC_L6;
      n_h0=CU*32*N_MC_H0; n_h1=CU*16*N_MC_H1;
      n_h2=CU*8*N_MC_H2;  n_h3=CU*8*N_MC_H3;
      n_h4=CU*4*N_MC_H4;  n_h5=CU*2*N_MC_H5;
      n_h6=CU*N_MC_H6;    n_b=CU*2*N_MC_B;
      n_l0=CU*32*N_MC_L0; n_l1=CU*16*N_MC_L1;
      n_l2=CU*8*N_MC_L2;  n_l3=CU*4*N_MC_L3;
      n_l4=CU*2*N_MC_L4;  n_l5=CU*2*N_MC_L5;
      n_l6=CU*N_MC_L6;

      p_ht=p_h0+p_h1+p_h2+p_h3+p_h4+p_h5+p_h6;
      p_lt=p_l0+p_l1+p_l2+p_l3+p_l4+p_l5+p_l6;
      n_ht=n_h0+n_h1+n_h2+n_h3+n_h4+n_h5+n_h6;
      n_lt=n_l0+n_l1+n_l2+n_l3+n_l4+n_l5+n_l6;
      p_a11=p_ht+p_b; p_a22=p_lt+p_b;
      p_det=p_a11*p_a22-p_b*p_b;
      p_i11=p_a22/p_det; p_i12=p_b/p_det;
      p_i21=p_b/p_det;   p_i22=p_a11/p_det;
      n_a11=n_ht+n_b; n_a22=n_lt+n_b;
      n_det=n_a11*n_a22-n_b*n_b;
      n_i11=n_a22/n_det; n_i12=n_b/n_det;
      n_i21=n_b/n_det;   n_i22=n_a11/n_det;
      sampled=0;
      qtp=0.0; qbp=0.0; qtn=0.0; qbn=0.0;
    end

    @(cross(V(sample)-SAMPLE_THRESHOLD_V,+1)) sampled=0;
    @(cross(V(sample)-SAMPLE_THRESHOLD_V,-1)) begin
      // All high and low physical capacitors sample their side's input.
      // VBRIDGE has no sampling clamp.  Its sampled voltage is the
      // capacitive-divider solution with VTOP=VCM and all low bottoms at VIN.
      vbp=(p_b*VCM_V+p_lt*V(vinp))/(p_b+p_lt);
      vbn=(n_b*VCM_V+n_lt*V(vinn))/(n_b+n_lt);
      qtp=p_ht*(VCM_V-V(vinp))+p_b*(VCM_V-vbp);
      qbp=p_b*(vbp-VCM_V)+p_lt*(vbp-V(vinp));
      qtn=n_ht*(VCM_V-V(vinn))+n_b*(VCM_V-vbn);
      qbn=n_b*(vbn-VCM_V)+n_lt*(vbn-V(vinn));
      sampled=1;
    end

    if (V(sample) > SAMPLE_THRESHOLD_V || !sampled) begin
      vtp=VCM_V;
      vbp=(p_b*VCM_V+p_lt*V(vinp))/(p_b+p_lt);
      vtn=VCM_V;
      vbn=(n_b*VCM_V+n_lt*V(vinn))/(n_b+n_lt);
    end else begin
      b1=qtp+p_h0*V(vbot_p_h0)+p_h1*V(vbot_p_h1)
            +p_h2*V(vbot_p_h2)+p_h3*V(vbot_p_h3)
            +p_h4*V(vbot_p_h4)+p_h5*V(vbot_p_h5)
            +p_h6*V(vbot_p_h6);
      b2=qbp+p_l0*V(vbot_p_l0)+p_l1*V(vbot_p_l1)
            +p_l2*V(vbot_p_l2)+p_l3*V(vbot_p_l3)
            +p_l4*V(vbot_p_l4)+p_l5*V(vbot_p_l5)
            +p_l6*V(vbot_p_l6);
      vtp=p_i11*b1+p_i12*b2;
      vbp=p_i21*b1+p_i22*b2;

      b1=qtn+n_h0*V(vbot_n_h0)+n_h1*V(vbot_n_h1)
            +n_h2*V(vbot_n_h2)+n_h3*V(vbot_n_h3)
            +n_h4*V(vbot_n_h4)+n_h5*V(vbot_n_h5)
            +n_h6*V(vbot_n_h6);
      b2=qbn+n_l0*V(vbot_n_l0)+n_l1*V(vbot_n_l1)
            +n_l2*V(vbot_n_l2)+n_l3*V(vbot_n_l3)
            +n_l4*V(vbot_n_l4)+n_l5*V(vbot_n_l5)
            +n_l6*V(vbot_n_l6);
      vtn=n_i11*b1+n_i12*b2;
      vbn=n_i21*b1+n_i22*b2;
    end

    V(vtop_p) <+ transition(vtp,0.0,TR_S,TR_S);
    V(vbridge_p) <+ transition(vbp,0.0,TR_S,TR_S);
    V(vtop_n) <+ transition(vtn,0.0,TR_S,TR_S);
    V(vbridge_n) <+ transition(vbn,0.0,TR_S,TR_S);
  end
endmodule
