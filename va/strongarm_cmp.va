// strongarm_cmp.va — clocked comparator behavioral model
//
// This is not a transistor StrongArm signoff model.  It provides a consistent
// polarity, optional offset/noise, input-dependent regeneration delay, and a
// real ready handshake for mixed-signal integration.

`include "constants.vams"
`include "disciplines.vams"

module strongarm_cmp(vtop_p, vtop_n, out, ready, clk);
  input vtop_p, vtop_n, clk;
  output out, ready;
  electrical vtop_p, vtop_n, clk, out, ready;

  parameter real T0_S = 0.5e-9 from [0:inf);
  parameter real TAU_S = 50e-12 from (0:inf);
  parameter real V_LOGIC = 1.8 from (0:inf);
  parameter real OFFSET_V = 0.0;
  parameter real NOISE_SIGMA_V = 0.0 from [0:inf);
  parameter real V_MIN = 1e-6 from (0:inf);
  parameter real MAX_WAIT_S = 10e-9 from (0:inf);
  parameter integer SEED = 1;
  parameter real TR_S = 10e-12 from [0:inf);

  integer noise_seed, result, ready_state;
  real vdiff_eff, abs_veff, decision_time, ready_at, noise_v;

  analog begin
    @(initial_step) begin
      noise_seed = SEED;
      result = 0;
      ready_state = 0;
      decision_time = T0_S;
      ready_at = 1.0e30;
      noise_v = 0.0;
    end

    @(cross(V(clk)-0.5*V_LOGIC,+1)) begin
      ready_state = 0;
      if (NOISE_SIGMA_V > 0.0)
        noise_v = NOISE_SIGMA_V
                  * $rdist_normal(noise_seed,0,1000000)/1000000.0;
      else
        noise_v = 0.0;

      vdiff_eff = V(vtop_p)-V(vtop_n)+OFFSET_V+noise_v;
      abs_veff = abs(vdiff_eff);
      result = (vdiff_eff > 0.0) ? 1 : 0;
      if (abs_veff < V_MIN)
        decision_time = MAX_WAIT_S;
      else begin
        decision_time = T0_S+TAU_S*ln(V_LOGIC/max(abs_veff,V_MIN));
        if (decision_time < T0_S) decision_time = T0_S;
        if (decision_time > MAX_WAIT_S) decision_time = MAX_WAIT_S;
      end
      ready_at = $abstime+decision_time;
    end

    @(timer(ready_at)) ready_state = 1;

    V(out) <+ transition(result*V_LOGIC,decision_time,TR_S,TR_S);
    V(ready) <+ transition(ready_state*V_LOGIC,0.0,TR_S,TR_S);
  end
endmodule
